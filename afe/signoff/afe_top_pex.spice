* SPICE3 file created from afe_top.ext - technology: gf180mcuD

.option scale=5n

X0 sh_final_0/c_samp_0/m4_n3120_n3000# sh_final_0/c_samp_0/m4_n3240_n3120# cap_mim_2f0_m4m5_noshield c_width=6000 c_length=6000
X1 sh_final_0/opamp_2stage_final_0/m2_nmos_0/a_n52_4348# sh_final_0/opamp_2stage_final_0/m2_nmos_0/a_n452_4256# sh_final_0/opamp_2stage_final_0/m2_nmos_0/a_n556_4348# VSUBS nfet_05v0 ad=0.208u pd=4.104m as=0.208u ps=4.104m w=4000 l=400
X2 sh_final_0/opamp_2stage_final_0/m2_nmos_0/a_n556_116# sh_final_0/opamp_2stage_final_0/m2_nmos_0/a_n956_24# sh_final_0/opamp_2stage_final_0/m2_nmos_0/a_n1044_116# VSUBS nfet_05v0 ad=0.208u pd=4.104m as=0.352u ps=8.176m w=4000 l=400
X3 sh_final_0/opamp_2stage_final_0/m2_nmos_0/a_n52_n4116# sh_final_0/opamp_2stage_final_0/m2_nmos_0/a_n452_n4208# sh_final_0/opamp_2stage_final_0/m2_nmos_0/a_n556_n4116# VSUBS nfet_05v0 ad=0.208u pd=4.104m as=0.208u ps=4.104m w=4000 l=400
X4 sh_final_0/opamp_2stage_final_0/m2_nmos_0/a_n52_n8348# sh_final_0/opamp_2stage_final_0/m2_nmos_0/a_n452_n8440# sh_final_0/opamp_2stage_final_0/m2_nmos_0/a_n556_n8348# VSUBS nfet_05v0 ad=0.208u pd=4.104m as=0.208u ps=4.104m w=4000 l=400
X5 sh_final_0/opamp_2stage_final_0/m2_nmos_0/a_956_116# sh_final_0/opamp_2stage_final_0/m2_nmos_0/a_556_24# sh_final_0/opamp_2stage_final_0/m2_nmos_0/a_452_116# VSUBS nfet_05v0 ad=0.352u pd=8.176m as=0.208u ps=4.104m w=4000 l=400
X6 sh_final_0/opamp_2stage_final_0/m2_nmos_0/a_452_4348# sh_final_0/opamp_2stage_final_0/m2_nmos_0/a_52_4256# sh_final_0/opamp_2stage_final_0/m2_nmos_0/a_n52_4348# VSUBS nfet_05v0 ad=0.208u pd=4.104m as=0.208u ps=4.104m w=4000 l=400
X7 sh_final_0/opamp_2stage_final_0/m2_nmos_0/a_452_116# sh_final_0/opamp_2stage_final_0/m2_nmos_0/a_52_24# sh_final_0/opamp_2stage_final_0/m2_nmos_0/a_n52_116# VSUBS nfet_05v0 ad=0.208u pd=4.104m as=0.208u ps=4.104m w=4000 l=400
X8 sh_final_0/opamp_2stage_final_0/m2_nmos_0/a_956_4348# sh_final_0/opamp_2stage_final_0/m2_nmos_0/a_556_4256# sh_final_0/opamp_2stage_final_0/m2_nmos_0/a_452_4348# VSUBS nfet_05v0 ad=0.352u pd=8.176m as=0.208u ps=4.104m w=4000 l=400
X9 sh_final_0/opamp_2stage_final_0/m2_nmos_0/a_n556_n4116# sh_final_0/opamp_2stage_final_0/m2_nmos_0/a_n956_n4208# sh_final_0/opamp_2stage_final_0/m2_nmos_0/a_n1044_n4116# VSUBS nfet_05v0 ad=0.208u pd=4.104m as=0.352u ps=8.176m w=4000 l=400
X10 sh_final_0/opamp_2stage_final_0/m2_nmos_0/a_n556_n8348# sh_final_0/opamp_2stage_final_0/m2_nmos_0/a_n956_n8440# sh_final_0/opamp_2stage_final_0/m2_nmos_0/a_n1044_n8348# VSUBS nfet_05v0 ad=0.208u pd=4.104m as=0.352u ps=8.176m w=4000 l=400
X11 sh_final_0/opamp_2stage_final_0/m2_nmos_0/a_956_n4116# sh_final_0/opamp_2stage_final_0/m2_nmos_0/a_556_n4208# sh_final_0/opamp_2stage_final_0/m2_nmos_0/a_452_n4116# VSUBS nfet_05v0 ad=0.352u pd=8.176m as=0.208u ps=4.104m w=4000 l=400
X12 sh_final_0/opamp_2stage_final_0/m2_nmos_0/a_956_n8348# sh_final_0/opamp_2stage_final_0/m2_nmos_0/a_556_n8440# sh_final_0/opamp_2stage_final_0/m2_nmos_0/a_452_n8348# VSUBS nfet_05v0 ad=0.352u pd=8.176m as=0.208u ps=4.104m w=4000 l=400
X13 sh_final_0/opamp_2stage_final_0/m2_nmos_0/a_452_n4116# sh_final_0/opamp_2stage_final_0/m2_nmos_0/a_52_n4208# sh_final_0/opamp_2stage_final_0/m2_nmos_0/a_n52_n4116# VSUBS nfet_05v0 ad=0.208u pd=4.104m as=0.208u ps=4.104m w=4000 l=400
X14 sh_final_0/opamp_2stage_final_0/m2_nmos_0/a_452_n8348# sh_final_0/opamp_2stage_final_0/m2_nmos_0/a_52_n8440# sh_final_0/opamp_2stage_final_0/m2_nmos_0/a_n52_n8348# VSUBS nfet_05v0 ad=0.208u pd=4.104m as=0.208u ps=4.104m w=4000 l=400
X15 sh_final_0/opamp_2stage_final_0/m2_nmos_0/a_n556_4348# sh_final_0/opamp_2stage_final_0/m2_nmos_0/a_n956_4256# sh_final_0/opamp_2stage_final_0/m2_nmos_0/a_n1044_4348# VSUBS nfet_05v0 ad=0.208u pd=4.104m as=0.352u ps=8.176m w=4000 l=400
X16 sh_final_0/opamp_2stage_final_0/m2_nmos_0/a_n52_116# sh_final_0/opamp_2stage_final_0/m2_nmos_0/a_n452_24# sh_final_0/opamp_2stage_final_0/m2_nmos_0/a_n556_116# VSUBS nfet_05v0 ad=0.208u pd=4.104m as=0.208u ps=4.104m w=4000 l=400
X17 sh_final_0/opamp_2stage_final_0/m6_pmos_0/a_n356_116# sh_final_0/opamp_2stage_final_0/m6_pmos_0/a_n556_24# sh_final_0/opamp_2stage_final_0/m6_pmos_0/a_n644_116# sh_final_0/opamp_2stage_final_0/m1_n2152_32500# pfet_05v0 ad=0.416u pd=8.104m as=0.704u ps=0.01618 w=8000 l=200
X18 sh_final_0/opamp_2stage_final_0/m1_n2152_32500# sh_final_0/opamp_2stage_final_0/m6_pmos_0/a_52_8256# sh_final_0/opamp_2stage_final_0/m1_n2152_32500# sh_final_0/opamp_2stage_final_0/m1_n2152_32500# pfet_05v0 ad=0.416u pd=8.104m as=0.416u ps=8.104m w=8000 l=200
X19 sh_final_0/opamp_2stage_final_0/m6_pmos_0/a_n52_n8116# sh_final_0/opamp_2stage_final_0/m6_pmos_0/a_n252_n8208# sh_final_0/opamp_2stage_final_0/m6_pmos_0/a_n356_n8116# sh_final_0/opamp_2stage_final_0/m1_n2152_32500# pfet_05v0 ad=0.416u pd=8.104m as=0.416u ps=8.104m w=8000 l=200
X20 sh_final_0/opamp_2stage_final_0/m1_n2152_32500# sh_final_0/opamp_2stage_final_0/m6_pmos_0/a_n252_8256# sh_final_0/opamp_2stage_final_0/m1_n2152_32500# sh_final_0/opamp_2stage_final_0/m1_n2152_32500# pfet_05v0 ad=0.416u pd=8.104m as=0.416u ps=8.104m w=8000 l=200
X21 sh_final_0/opamp_2stage_final_0/m6_pmos_0/a_n52_116# sh_final_0/opamp_2stage_final_0/m6_pmos_0/a_n252_24# sh_final_0/opamp_2stage_final_0/m6_pmos_0/a_n356_116# sh_final_0/opamp_2stage_final_0/m1_n2152_32500# pfet_05v0 ad=0.416u pd=8.104m as=0.416u ps=8.104m w=8000 l=200
X22 sh_final_0/opamp_2stage_final_0/m6_pmos_0/a_252_116# sh_final_0/opamp_2stage_final_0/m6_pmos_0/a_52_24# sh_final_0/opamp_2stage_final_0/m6_pmos_0/a_n52_116# sh_final_0/opamp_2stage_final_0/m1_n2152_32500# pfet_05v0 ad=0.416u pd=8.104m as=0.416u ps=8.104m w=8000 l=200
X23 sh_final_0/opamp_2stage_final_0/m1_n2152_32500# sh_final_0/opamp_2stage_final_0/m6_pmos_0/a_356_n16440# sh_final_0/opamp_2stage_final_0/m1_n2152_32500# sh_final_0/opamp_2stage_final_0/m1_n2152_32500# pfet_05v0 ad=0.704u pd=0.01618 as=0.416u ps=8.104m w=8000 l=200
X24 sh_final_0/opamp_2stage_final_0/m1_n2152_32500# sh_final_0/opamp_2stage_final_0/m6_pmos_0/a_n556_8256# sh_final_0/opamp_2stage_final_0/m1_n2152_32500# sh_final_0/opamp_2stage_final_0/m1_n2152_32500# pfet_05v0 ad=0.416u pd=8.104m as=0.704u ps=0.01618 w=8000 l=200
X25 sh_final_0/opamp_2stage_final_0/m6_pmos_0/a_252_n8116# sh_final_0/opamp_2stage_final_0/m6_pmos_0/a_52_n8208# sh_final_0/opamp_2stage_final_0/m6_pmos_0/a_n52_n8116# sh_final_0/opamp_2stage_final_0/m1_n2152_32500# pfet_05v0 ad=0.416u pd=8.104m as=0.416u ps=8.104m w=8000 l=200
X26 sh_final_0/opamp_2stage_final_0/m1_n2152_32500# sh_final_0/opamp_2stage_final_0/m6_pmos_0/a_52_n16440# sh_final_0/opamp_2stage_final_0/m1_n2152_32500# sh_final_0/opamp_2stage_final_0/m1_n2152_32500# pfet_05v0 ad=0.416u pd=8.104m as=0.416u ps=8.104m w=8000 l=200
X27 sh_final_0/opamp_2stage_final_0/m6_pmos_0/a_556_n8116# sh_final_0/opamp_2stage_final_0/m6_pmos_0/a_356_n8208# sh_final_0/opamp_2stage_final_0/m6_pmos_0/a_252_n8116# sh_final_0/opamp_2stage_final_0/m1_n2152_32500# pfet_05v0 ad=0.704u pd=0.01618 as=0.416u ps=8.104m w=8000 l=200
X28 sh_final_0/opamp_2stage_final_0/m6_pmos_0/a_n356_n8116# sh_final_0/opamp_2stage_final_0/m6_pmos_0/a_n556_n8208# sh_final_0/opamp_2stage_final_0/m6_pmos_0/a_n644_n8116# sh_final_0/opamp_2stage_final_0/m1_n2152_32500# pfet_05v0 ad=0.416u pd=8.104m as=0.704u ps=0.01618 w=8000 l=200
X29 sh_final_0/opamp_2stage_final_0/m1_n2152_32500# sh_final_0/opamp_2stage_final_0/m6_pmos_0/a_n556_n16440# sh_final_0/opamp_2stage_final_0/m1_n2152_32500# sh_final_0/opamp_2stage_final_0/m1_n2152_32500# pfet_05v0 ad=0.416u pd=8.104m as=0.704u ps=0.01618 w=8000 l=200
X30 sh_final_0/opamp_2stage_final_0/m1_n2152_32500# sh_final_0/opamp_2stage_final_0/m6_pmos_0/a_356_8256# sh_final_0/opamp_2stage_final_0/m1_n2152_32500# sh_final_0/opamp_2stage_final_0/m1_n2152_32500# pfet_05v0 ad=0.704u pd=0.01618 as=0.416u ps=8.104m w=8000 l=200
X31 sh_final_0/opamp_2stage_final_0/m6_pmos_0/a_556_116# sh_final_0/opamp_2stage_final_0/m6_pmos_0/a_356_24# sh_final_0/opamp_2stage_final_0/m6_pmos_0/a_252_116# sh_final_0/opamp_2stage_final_0/m1_n2152_32500# pfet_05v0 ad=0.704u pd=0.01618 as=0.416u ps=8.104m w=8000 l=200
X32 sh_final_0/opamp_2stage_final_0/m1_n2152_32500# sh_final_0/opamp_2stage_final_0/m6_pmos_0/a_n252_n16440# sh_final_0/opamp_2stage_final_0/m1_n2152_32500# sh_final_0/opamp_2stage_final_0/m1_n2152_32500# pfet_05v0 ad=0.416u pd=8.104m as=0.416u ps=8.104m w=8000 l=200
X33 sh_final_0/opamp_2stage_final_0/m5_nmos_0/a_n52_2348# sh_final_0/opamp_2stage_final_0/m5_nmos_0/a_n452_2256# sh_final_0/opamp_2stage_final_0/m5_nmos_0/a_n556_2348# VSUBS nfet_05v0 ad=0.104u pd=2.104m as=0.104u ps=2.104m w=2000 l=400
X34 sh_final_0/opamp_2stage_final_0/m5_nmos_0/a_n556_116# sh_final_0/opamp_2stage_final_0/m5_nmos_0/a_n956_24# sh_final_0/opamp_2stage_final_0/m5_nmos_0/a_n1044_116# VSUBS nfet_05v0 ad=0.104u pd=2.104m as=0.176u ps=4.176m w=2000 l=400
X35 sh_final_0/opamp_2stage_final_0/m5_nmos_0/a_956_116# sh_final_0/opamp_2stage_final_0/m5_nmos_0/a_556_24# sh_final_0/opamp_2stage_final_0/m5_nmos_0/a_452_116# VSUBS nfet_05v0 ad=0.176u pd=4.176m as=0.104u ps=2.104m w=2000 l=400
X36 sh_final_0/opamp_2stage_final_0/m5_nmos_0/a_n52_n2116# sh_final_0/opamp_2stage_final_0/m5_nmos_0/a_n452_n2208# sh_final_0/opamp_2stage_final_0/m5_nmos_0/a_n556_n2116# VSUBS nfet_05v0 ad=0.104u pd=2.104m as=0.104u ps=2.104m w=2000 l=400
X37 sh_final_0/opamp_2stage_final_0/m5_nmos_0/a_n52_n4348# sh_final_0/opamp_2stage_final_0/m5_nmos_0/a_n452_n4440# sh_final_0/opamp_2stage_final_0/m5_nmos_0/a_n556_n4348# VSUBS nfet_05v0 ad=0.104u pd=2.104m as=0.104u ps=2.104m w=2000 l=400
X38 sh_final_0/opamp_2stage_final_0/m5_nmos_0/a_452_116# sh_final_0/opamp_2stage_final_0/m5_nmos_0/a_52_24# sh_final_0/opamp_2stage_final_0/m5_nmos_0/a_n52_116# VSUBS nfet_05v0 ad=0.104u pd=2.104m as=0.104u ps=2.104m w=2000 l=400
X39 sh_final_0/opamp_2stage_final_0/m5_nmos_0/a_452_2348# sh_final_0/opamp_2stage_final_0/m5_nmos_0/a_52_2256# sh_final_0/opamp_2stage_final_0/m5_nmos_0/a_n52_2348# VSUBS nfet_05v0 ad=0.104u pd=2.104m as=0.104u ps=2.104m w=2000 l=400
X40 sh_final_0/opamp_2stage_final_0/m5_nmos_0/a_956_2348# sh_final_0/opamp_2stage_final_0/m5_nmos_0/a_556_2256# sh_final_0/opamp_2stage_final_0/m5_nmos_0/a_452_2348# VSUBS nfet_05v0 ad=0.176u pd=4.176m as=0.104u ps=2.104m w=2000 l=400
X41 sh_final_0/opamp_2stage_final_0/m5_nmos_0/a_n556_n2116# sh_final_0/opamp_2stage_final_0/m5_nmos_0/a_n956_n2208# sh_final_0/opamp_2stage_final_0/m5_nmos_0/a_n1044_n2116# VSUBS nfet_05v0 ad=0.104u pd=2.104m as=0.176u ps=4.176m w=2000 l=400
X42 sh_final_0/opamp_2stage_final_0/m5_nmos_0/a_956_n2116# sh_final_0/opamp_2stage_final_0/m5_nmos_0/a_556_n2208# sh_final_0/opamp_2stage_final_0/m5_nmos_0/a_452_n2116# VSUBS nfet_05v0 ad=0.176u pd=4.176m as=0.104u ps=2.104m w=2000 l=400
X43 sh_final_0/opamp_2stage_final_0/m5_nmos_0/a_n556_n4348# sh_final_0/opamp_2stage_final_0/m5_nmos_0/a_n956_n4440# sh_final_0/opamp_2stage_final_0/m5_nmos_0/a_n1044_n4348# VSUBS nfet_05v0 ad=0.104u pd=2.104m as=0.176u ps=4.176m w=2000 l=400
X44 sh_final_0/opamp_2stage_final_0/m5_nmos_0/a_452_n2116# sh_final_0/opamp_2stage_final_0/m5_nmos_0/a_52_n2208# sh_final_0/opamp_2stage_final_0/m5_nmos_0/a_n52_n2116# VSUBS nfet_05v0 ad=0.104u pd=2.104m as=0.104u ps=2.104m w=2000 l=400
X45 sh_final_0/opamp_2stage_final_0/m5_nmos_0/a_n556_2348# sh_final_0/opamp_2stage_final_0/m5_nmos_0/a_n956_2256# sh_final_0/opamp_2stage_final_0/m5_nmos_0/a_n1044_2348# VSUBS nfet_05v0 ad=0.104u pd=2.104m as=0.176u ps=4.176m w=2000 l=400
X46 sh_final_0/opamp_2stage_final_0/m5_nmos_0/a_n52_116# sh_final_0/opamp_2stage_final_0/m5_nmos_0/a_n452_24# sh_final_0/opamp_2stage_final_0/m5_nmos_0/a_n556_116# VSUBS nfet_05v0 ad=0.104u pd=2.104m as=0.104u ps=2.104m w=2000 l=400
X47 sh_final_0/opamp_2stage_final_0/m5_nmos_0/a_452_n4348# sh_final_0/opamp_2stage_final_0/m5_nmos_0/a_52_n4440# sh_final_0/opamp_2stage_final_0/m5_nmos_0/a_n52_n4348# VSUBS nfet_05v0 ad=0.104u pd=2.104m as=0.104u ps=2.104m w=2000 l=400
X48 sh_final_0/opamp_2stage_final_0/m5_nmos_0/a_956_n4348# sh_final_0/opamp_2stage_final_0/m5_nmos_0/a_556_n4440# sh_final_0/opamp_2stage_final_0/m5_nmos_0/a_452_n4348# VSUBS nfet_05v0 ad=0.176u pd=4.176m as=0.104u ps=2.104m w=2000 l=400
X49 sh_final_0/opamp_2stage_final_0/m3_pmos_0/a_n556_116# sh_final_0/opamp_2stage_final_0/m3_pmos_0/a_n956_24# sh_final_0/opamp_2stage_final_0/m3_pmos_0/a_n1044_116# sh_final_0/opamp_2stage_final_0/m3_pmos_0/w_n1220_n4604# pfet_05v0 ad=0.104u pd=2.104m as=0.176u ps=4.176m w=2000 l=400
X50 sh_final_0/opamp_2stage_final_0/m3_pmos_0/a_n52_2348# sh_final_0/opamp_2stage_final_0/m3_pmos_0/a_n452_2256# sh_final_0/opamp_2stage_final_0/m3_pmos_0/a_n556_2348# sh_final_0/opamp_2stage_final_0/m3_pmos_0/w_n1220_n4604# pfet_05v0 ad=0.104u pd=2.104m as=0.104u ps=2.104m w=2000 l=400
X51 sh_final_0/opamp_2stage_final_0/m3_pmos_0/a_956_116# sh_final_0/opamp_2stage_final_0/m3_pmos_0/a_556_24# sh_final_0/opamp_2stage_final_0/m3_pmos_0/a_452_116# sh_final_0/opamp_2stage_final_0/m3_pmos_0/w_n1220_n4604# pfet_05v0 ad=0.176u pd=4.176m as=0.104u ps=2.104m w=2000 l=400
X52 sh_final_0/opamp_2stage_final_0/m3_pmos_0/a_n52_n2116# sh_final_0/opamp_2stage_final_0/m3_pmos_0/a_n452_n2208# sh_final_0/opamp_2stage_final_0/m3_pmos_0/a_n556_n2116# sh_final_0/opamp_2stage_final_0/m3_pmos_0/w_n1220_n4604# pfet_05v0 ad=0.104u pd=2.104m as=0.104u ps=2.104m w=2000 l=400
X53 sh_final_0/opamp_2stage_final_0/m3_pmos_0/a_n52_n4348# sh_final_0/opamp_2stage_final_0/m3_pmos_0/a_n452_n4440# sh_final_0/opamp_2stage_final_0/m3_pmos_0/a_n556_n4348# sh_final_0/opamp_2stage_final_0/m3_pmos_0/w_n1220_n4604# pfet_05v0 ad=0.104u pd=2.104m as=0.104u ps=2.104m w=2000 l=400
X54 sh_final_0/opamp_2stage_final_0/m3_pmos_0/a_452_116# sh_final_0/opamp_2stage_final_0/m3_pmos_0/a_52_24# sh_final_0/opamp_2stage_final_0/m3_pmos_0/a_n52_116# sh_final_0/opamp_2stage_final_0/m3_pmos_0/w_n1220_n4604# pfet_05v0 ad=0.104u pd=2.104m as=0.104u ps=2.104m w=2000 l=400
X55 sh_final_0/opamp_2stage_final_0/m3_pmos_0/a_452_2348# sh_final_0/opamp_2stage_final_0/m3_pmos_0/a_52_2256# sh_final_0/opamp_2stage_final_0/m3_pmos_0/a_n52_2348# sh_final_0/opamp_2stage_final_0/m3_pmos_0/w_n1220_n4604# pfet_05v0 ad=0.104u pd=2.104m as=0.104u ps=2.104m w=2000 l=400
X56 sh_final_0/opamp_2stage_final_0/m3_pmos_0/a_956_2348# sh_final_0/opamp_2stage_final_0/m3_pmos_0/a_556_2256# sh_final_0/opamp_2stage_final_0/m3_pmos_0/a_452_2348# sh_final_0/opamp_2stage_final_0/m3_pmos_0/w_n1220_n4604# pfet_05v0 ad=0.176u pd=4.176m as=0.104u ps=2.104m w=2000 l=400
X57 sh_final_0/opamp_2stage_final_0/m3_pmos_0/a_n556_n2116# sh_final_0/opamp_2stage_final_0/m3_pmos_0/a_n956_n2208# sh_final_0/opamp_2stage_final_0/m3_pmos_0/a_n1044_n2116# sh_final_0/opamp_2stage_final_0/m3_pmos_0/w_n1220_n4604# pfet_05v0 ad=0.104u pd=2.104m as=0.176u ps=4.176m w=2000 l=400
X58 sh_final_0/opamp_2stage_final_0/m3_pmos_0/a_956_n2116# sh_final_0/opamp_2stage_final_0/m3_pmos_0/a_556_n2208# sh_final_0/opamp_2stage_final_0/m3_pmos_0/a_452_n2116# sh_final_0/opamp_2stage_final_0/m3_pmos_0/w_n1220_n4604# pfet_05v0 ad=0.176u pd=4.176m as=0.104u ps=2.104m w=2000 l=400
X59 sh_final_0/opamp_2stage_final_0/m3_pmos_0/a_n556_n4348# sh_final_0/opamp_2stage_final_0/m3_pmos_0/a_n956_n4440# sh_final_0/opamp_2stage_final_0/m3_pmos_0/a_n1044_n4348# sh_final_0/opamp_2stage_final_0/m3_pmos_0/w_n1220_n4604# pfet_05v0 ad=0.104u pd=2.104m as=0.176u ps=4.176m w=2000 l=400
X60 sh_final_0/opamp_2stage_final_0/m3_pmos_0/a_452_n2116# sh_final_0/opamp_2stage_final_0/m3_pmos_0/a_52_n2208# sh_final_0/opamp_2stage_final_0/m3_pmos_0/a_n52_n2116# sh_final_0/opamp_2stage_final_0/m3_pmos_0/w_n1220_n4604# pfet_05v0 ad=0.104u pd=2.104m as=0.104u ps=2.104m w=2000 l=400
X61 sh_final_0/opamp_2stage_final_0/m3_pmos_0/a_n556_2348# sh_final_0/opamp_2stage_final_0/m3_pmos_0/a_n956_2256# sh_final_0/opamp_2stage_final_0/m3_pmos_0/a_n1044_2348# sh_final_0/opamp_2stage_final_0/m3_pmos_0/w_n1220_n4604# pfet_05v0 ad=0.104u pd=2.104m as=0.176u ps=4.176m w=2000 l=400
X62 sh_final_0/opamp_2stage_final_0/m3_pmos_0/a_n52_116# sh_final_0/opamp_2stage_final_0/m3_pmos_0/a_n452_24# sh_final_0/opamp_2stage_final_0/m3_pmos_0/a_n556_116# sh_final_0/opamp_2stage_final_0/m3_pmos_0/w_n1220_n4604# pfet_05v0 ad=0.104u pd=2.104m as=0.104u ps=2.104m w=2000 l=400
X63 sh_final_0/opamp_2stage_final_0/m3_pmos_0/a_452_n4348# sh_final_0/opamp_2stage_final_0/m3_pmos_0/a_52_n4440# sh_final_0/opamp_2stage_final_0/m3_pmos_0/a_n52_n4348# sh_final_0/opamp_2stage_final_0/m3_pmos_0/w_n1220_n4604# pfet_05v0 ad=0.104u pd=2.104m as=0.104u ps=2.104m w=2000 l=400
X64 sh_final_0/opamp_2stage_final_0/m3_pmos_0/a_956_n4348# sh_final_0/opamp_2stage_final_0/m3_pmos_0/a_556_n4440# sh_final_0/opamp_2stage_final_0/m3_pmos_0/a_452_n4348# sh_final_0/opamp_2stage_final_0/m3_pmos_0/w_n1220_n4604# pfet_05v0 ad=0.176u pd=4.176m as=0.104u ps=2.104m w=2000 l=400
X65 sh_final_0/opamp_2stage_final_0/m4_pmos_0/a_n556_116# sh_final_0/opamp_2stage_final_0/m4_pmos_0/a_n956_24# sh_final_0/opamp_2stage_final_0/m4_pmos_0/a_n1044_116# sh_final_0/opamp_2stage_final_0/m4_pmos_0/w_n1220_n4604# pfet_05v0 ad=0.104u pd=2.104m as=0.176u ps=4.176m w=2000 l=400
X66 sh_final_0/opamp_2stage_final_0/m4_pmos_0/a_n52_2348# sh_final_0/opamp_2stage_final_0/m4_pmos_0/a_n452_2256# sh_final_0/opamp_2stage_final_0/m4_pmos_0/a_n556_2348# sh_final_0/opamp_2stage_final_0/m4_pmos_0/w_n1220_n4604# pfet_05v0 ad=0.104u pd=2.104m as=0.104u ps=2.104m w=2000 l=400
X67 sh_final_0/opamp_2stage_final_0/m4_pmos_0/a_956_116# sh_final_0/opamp_2stage_final_0/m4_pmos_0/a_556_24# sh_final_0/opamp_2stage_final_0/m4_pmos_0/a_452_116# sh_final_0/opamp_2stage_final_0/m4_pmos_0/w_n1220_n4604# pfet_05v0 ad=0.176u pd=4.176m as=0.104u ps=2.104m w=2000 l=400
X68 sh_final_0/opamp_2stage_final_0/m4_pmos_0/a_n52_n2116# sh_final_0/opamp_2stage_final_0/m4_pmos_0/a_n452_n2208# sh_final_0/opamp_2stage_final_0/m4_pmos_0/a_n556_n2116# sh_final_0/opamp_2stage_final_0/m4_pmos_0/w_n1220_n4604# pfet_05v0 ad=0.104u pd=2.104m as=0.104u ps=2.104m w=2000 l=400
X69 sh_final_0/opamp_2stage_final_0/m4_pmos_0/a_n52_n4348# sh_final_0/opamp_2stage_final_0/m4_pmos_0/a_n452_n4440# sh_final_0/opamp_2stage_final_0/m4_pmos_0/a_n556_n4348# sh_final_0/opamp_2stage_final_0/m4_pmos_0/w_n1220_n4604# pfet_05v0 ad=0.104u pd=2.104m as=0.104u ps=2.104m w=2000 l=400
X70 sh_final_0/opamp_2stage_final_0/m4_pmos_0/a_452_116# sh_final_0/opamp_2stage_final_0/m4_pmos_0/a_52_24# sh_final_0/opamp_2stage_final_0/m4_pmos_0/a_n52_116# sh_final_0/opamp_2stage_final_0/m4_pmos_0/w_n1220_n4604# pfet_05v0 ad=0.104u pd=2.104m as=0.104u ps=2.104m w=2000 l=400
X71 sh_final_0/opamp_2stage_final_0/m4_pmos_0/a_452_2348# sh_final_0/opamp_2stage_final_0/m4_pmos_0/a_52_2256# sh_final_0/opamp_2stage_final_0/m4_pmos_0/a_n52_2348# sh_final_0/opamp_2stage_final_0/m4_pmos_0/w_n1220_n4604# pfet_05v0 ad=0.104u pd=2.104m as=0.104u ps=2.104m w=2000 l=400
X72 sh_final_0/opamp_2stage_final_0/m4_pmos_0/a_956_2348# sh_final_0/opamp_2stage_final_0/m4_pmos_0/a_556_2256# sh_final_0/opamp_2stage_final_0/m4_pmos_0/a_452_2348# sh_final_0/opamp_2stage_final_0/m4_pmos_0/w_n1220_n4604# pfet_05v0 ad=0.176u pd=4.176m as=0.104u ps=2.104m w=2000 l=400
X73 sh_final_0/opamp_2stage_final_0/m4_pmos_0/a_n556_n2116# sh_final_0/opamp_2stage_final_0/m4_pmos_0/a_n956_n2208# sh_final_0/opamp_2stage_final_0/m4_pmos_0/a_n1044_n2116# sh_final_0/opamp_2stage_final_0/m4_pmos_0/w_n1220_n4604# pfet_05v0 ad=0.104u pd=2.104m as=0.176u ps=4.176m w=2000 l=400
X74 sh_final_0/opamp_2stage_final_0/m4_pmos_0/a_956_n2116# sh_final_0/opamp_2stage_final_0/m4_pmos_0/a_556_n2208# sh_final_0/opamp_2stage_final_0/m4_pmos_0/a_452_n2116# sh_final_0/opamp_2stage_final_0/m4_pmos_0/w_n1220_n4604# pfet_05v0 ad=0.176u pd=4.176m as=0.104u ps=2.104m w=2000 l=400
X75 sh_final_0/opamp_2stage_final_0/m4_pmos_0/a_n556_n4348# sh_final_0/opamp_2stage_final_0/m4_pmos_0/a_n956_n4440# sh_final_0/opamp_2stage_final_0/m4_pmos_0/a_n1044_n4348# sh_final_0/opamp_2stage_final_0/m4_pmos_0/w_n1220_n4604# pfet_05v0 ad=0.104u pd=2.104m as=0.176u ps=4.176m w=2000 l=400
X76 sh_final_0/opamp_2stage_final_0/m4_pmos_0/a_452_n2116# sh_final_0/opamp_2stage_final_0/m4_pmos_0/a_52_n2208# sh_final_0/opamp_2stage_final_0/m4_pmos_0/a_n52_n2116# sh_final_0/opamp_2stage_final_0/m4_pmos_0/w_n1220_n4604# pfet_05v0 ad=0.104u pd=2.104m as=0.104u ps=2.104m w=2000 l=400
X77 sh_final_0/opamp_2stage_final_0/m4_pmos_0/a_n556_2348# sh_final_0/opamp_2stage_final_0/m4_pmos_0/a_n956_2256# sh_final_0/opamp_2stage_final_0/m4_pmos_0/a_n1044_2348# sh_final_0/opamp_2stage_final_0/m4_pmos_0/w_n1220_n4604# pfet_05v0 ad=0.104u pd=2.104m as=0.176u ps=4.176m w=2000 l=400
X78 sh_final_0/opamp_2stage_final_0/m4_pmos_0/a_n52_116# sh_final_0/opamp_2stage_final_0/m4_pmos_0/a_n452_24# sh_final_0/opamp_2stage_final_0/m4_pmos_0/a_n556_116# sh_final_0/opamp_2stage_final_0/m4_pmos_0/w_n1220_n4604# pfet_05v0 ad=0.104u pd=2.104m as=0.104u ps=2.104m w=2000 l=400
X79 sh_final_0/opamp_2stage_final_0/m4_pmos_0/a_452_n4348# sh_final_0/opamp_2stage_final_0/m4_pmos_0/a_52_n4440# sh_final_0/opamp_2stage_final_0/m4_pmos_0/a_n52_n4348# sh_final_0/opamp_2stage_final_0/m4_pmos_0/w_n1220_n4604# pfet_05v0 ad=0.104u pd=2.104m as=0.104u ps=2.104m w=2000 l=400
X80 sh_final_0/opamp_2stage_final_0/m4_pmos_0/a_956_n4348# sh_final_0/opamp_2stage_final_0/m4_pmos_0/a_556_n4440# sh_final_0/opamp_2stage_final_0/m4_pmos_0/a_452_n4348# sh_final_0/opamp_2stage_final_0/m4_pmos_0/w_n1220_n4604# pfet_05v0 ad=0.176u pd=4.176m as=0.104u ps=2.104m w=2000 l=400
X81 sh_final_0/opamp_2stage_final_0/m1_nmos_0/a_n52_4348# sh_final_0/opamp_2stage_final_0/m1_nmos_0/a_n452_4256# sh_final_0/opamp_2stage_final_0/m1_nmos_0/a_n556_4348# VSUBS nfet_05v0 ad=0.208u pd=4.104m as=0.208u ps=4.104m w=4000 l=400
X82 sh_final_0/opamp_2stage_final_0/m1_nmos_0/a_n556_116# sh_final_0/opamp_2stage_final_0/m1_nmos_0/a_n956_24# sh_final_0/opamp_2stage_final_0/m1_nmos_0/a_n1044_116# VSUBS nfet_05v0 ad=0.208u pd=4.104m as=0.352u ps=8.176m w=4000 l=400
X83 sh_final_0/opamp_2stage_final_0/m1_nmos_0/a_n52_n4116# sh_final_0/opamp_2stage_final_0/m1_nmos_0/a_n452_n4208# sh_final_0/opamp_2stage_final_0/m1_nmos_0/a_n556_n4116# VSUBS nfet_05v0 ad=0.208u pd=4.104m as=0.208u ps=4.104m w=4000 l=400
X84 sh_final_0/opamp_2stage_final_0/m1_nmos_0/a_n52_n8348# sh_final_0/opamp_2stage_final_0/m1_nmos_0/a_n452_n8440# sh_final_0/opamp_2stage_final_0/m1_nmos_0/a_n556_n8348# VSUBS nfet_05v0 ad=0.208u pd=4.104m as=0.208u ps=4.104m w=4000 l=400
X85 sh_final_0/opamp_2stage_final_0/m1_nmos_0/a_956_116# sh_final_0/opamp_2stage_final_0/m1_nmos_0/a_556_24# sh_final_0/opamp_2stage_final_0/m1_nmos_0/a_452_116# VSUBS nfet_05v0 ad=0.352u pd=8.176m as=0.208u ps=4.104m w=4000 l=400
X86 sh_final_0/opamp_2stage_final_0/m1_nmos_0/a_452_4348# sh_final_0/opamp_2stage_final_0/m1_nmos_0/a_52_4256# sh_final_0/opamp_2stage_final_0/m1_nmos_0/a_n52_4348# VSUBS nfet_05v0 ad=0.208u pd=4.104m as=0.208u ps=4.104m w=4000 l=400
X87 sh_final_0/opamp_2stage_final_0/m1_nmos_0/a_452_116# sh_final_0/opamp_2stage_final_0/m1_nmos_0/a_52_24# sh_final_0/opamp_2stage_final_0/m1_nmos_0/a_n52_116# VSUBS nfet_05v0 ad=0.208u pd=4.104m as=0.208u ps=4.104m w=4000 l=400
X88 sh_final_0/opamp_2stage_final_0/m1_nmos_0/a_956_4348# sh_final_0/opamp_2stage_final_0/m1_nmos_0/a_556_4256# sh_final_0/opamp_2stage_final_0/m1_nmos_0/a_452_4348# VSUBS nfet_05v0 ad=0.352u pd=8.176m as=0.208u ps=4.104m w=4000 l=400
X89 sh_final_0/opamp_2stage_final_0/m1_nmos_0/a_n556_n4116# sh_final_0/opamp_2stage_final_0/m1_nmos_0/a_n956_n4208# sh_final_0/opamp_2stage_final_0/m1_nmos_0/a_n1044_n4116# VSUBS nfet_05v0 ad=0.208u pd=4.104m as=0.352u ps=8.176m w=4000 l=400
X90 sh_final_0/opamp_2stage_final_0/m1_nmos_0/a_n556_n8348# sh_final_0/opamp_2stage_final_0/m1_nmos_0/a_n956_n8440# sh_final_0/opamp_2stage_final_0/m1_nmos_0/a_n1044_n8348# VSUBS nfet_05v0 ad=0.208u pd=4.104m as=0.352u ps=8.176m w=4000 l=400
X91 sh_final_0/opamp_2stage_final_0/m1_nmos_0/a_956_n4116# sh_final_0/opamp_2stage_final_0/m1_nmos_0/a_556_n4208# sh_final_0/opamp_2stage_final_0/m1_nmos_0/a_452_n4116# VSUBS nfet_05v0 ad=0.352u pd=8.176m as=0.208u ps=4.104m w=4000 l=400
X92 sh_final_0/opamp_2stage_final_0/m1_nmos_0/a_956_n8348# sh_final_0/opamp_2stage_final_0/m1_nmos_0/a_556_n8440# sh_final_0/opamp_2stage_final_0/m1_nmos_0/a_452_n8348# VSUBS nfet_05v0 ad=0.352u pd=8.176m as=0.208u ps=4.104m w=4000 l=400
X93 sh_final_0/opamp_2stage_final_0/m1_nmos_0/a_452_n4116# sh_final_0/opamp_2stage_final_0/m1_nmos_0/a_52_n4208# sh_final_0/opamp_2stage_final_0/m1_nmos_0/a_n52_n4116# VSUBS nfet_05v0 ad=0.208u pd=4.104m as=0.208u ps=4.104m w=4000 l=400
X94 sh_final_0/opamp_2stage_final_0/m1_nmos_0/a_452_n8348# sh_final_0/opamp_2stage_final_0/m1_nmos_0/a_52_n8440# sh_final_0/opamp_2stage_final_0/m1_nmos_0/a_n52_n8348# VSUBS nfet_05v0 ad=0.208u pd=4.104m as=0.208u ps=4.104m w=4000 l=400
X95 sh_final_0/opamp_2stage_final_0/m1_nmos_0/a_n556_4348# sh_final_0/opamp_2stage_final_0/m1_nmos_0/a_n956_4256# sh_final_0/opamp_2stage_final_0/m1_nmos_0/a_n1044_4348# VSUBS nfet_05v0 ad=0.208u pd=4.104m as=0.352u ps=8.176m w=4000 l=400
X96 sh_final_0/opamp_2stage_final_0/m1_nmos_0/a_n52_116# sh_final_0/opamp_2stage_final_0/m1_nmos_0/a_n452_24# sh_final_0/opamp_2stage_final_0/m1_nmos_0/a_n556_116# VSUBS nfet_05v0 ad=0.208u pd=4.104m as=0.208u ps=4.104m w=4000 l=400
X97 sh_final_0/opamp_2stage_final_0/m7_nmos_0/a_n52_4348# sh_final_0/opamp_2stage_final_0/m7_nmos_0/a_n452_4256# sh_final_0/opamp_2stage_final_0/m7_nmos_0/a_n556_4348# VSUBS nfet_05v0 ad=0.208u pd=4.104m as=0.208u ps=4.104m w=4000 l=400
X98 sh_final_0/opamp_2stage_final_0/m7_nmos_0/a_n556_116# sh_final_0/opamp_2stage_final_0/m7_nmos_0/a_n956_24# sh_final_0/opamp_2stage_final_0/m7_nmos_0/a_n1044_116# VSUBS nfet_05v0 ad=0.208u pd=4.104m as=0.352u ps=8.176m w=4000 l=400
X99 sh_final_0/opamp_2stage_final_0/m7_nmos_0/a_n52_n4116# sh_final_0/opamp_2stage_final_0/m7_nmos_0/a_n452_n4208# sh_final_0/opamp_2stage_final_0/m7_nmos_0/a_n556_n4116# VSUBS nfet_05v0 ad=0.208u pd=4.104m as=0.208u ps=4.104m w=4000 l=400
X100 sh_final_0/opamp_2stage_final_0/m7_nmos_0/a_n52_n8348# sh_final_0/opamp_2stage_final_0/m7_nmos_0/a_n452_n8440# sh_final_0/opamp_2stage_final_0/m7_nmos_0/a_n556_n8348# VSUBS nfet_05v0 ad=0.208u pd=4.104m as=0.208u ps=4.104m w=4000 l=400
X101 sh_final_0/opamp_2stage_final_0/m7_nmos_0/a_956_116# sh_final_0/opamp_2stage_final_0/m7_nmos_0/a_556_24# sh_final_0/opamp_2stage_final_0/m7_nmos_0/a_452_116# VSUBS nfet_05v0 ad=0.352u pd=8.176m as=0.208u ps=4.104m w=4000 l=400
X102 sh_final_0/opamp_2stage_final_0/m7_nmos_0/a_452_4348# sh_final_0/opamp_2stage_final_0/m7_nmos_0/a_52_4256# sh_final_0/opamp_2stage_final_0/m7_nmos_0/a_n52_4348# VSUBS nfet_05v0 ad=0.208u pd=4.104m as=0.208u ps=4.104m w=4000 l=400
X103 sh_final_0/opamp_2stage_final_0/m7_nmos_0/a_452_116# sh_final_0/opamp_2stage_final_0/m7_nmos_0/a_52_24# sh_final_0/opamp_2stage_final_0/m7_nmos_0/a_n52_116# VSUBS nfet_05v0 ad=0.208u pd=4.104m as=0.208u ps=4.104m w=4000 l=400
X104 sh_final_0/opamp_2stage_final_0/m7_nmos_0/a_956_4348# sh_final_0/opamp_2stage_final_0/m7_nmos_0/a_556_4256# sh_final_0/opamp_2stage_final_0/m7_nmos_0/a_452_4348# VSUBS nfet_05v0 ad=0.352u pd=8.176m as=0.208u ps=4.104m w=4000 l=400
X105 sh_final_0/opamp_2stage_final_0/m7_nmos_0/a_n556_n4116# sh_final_0/opamp_2stage_final_0/m7_nmos_0/a_n956_n4208# sh_final_0/opamp_2stage_final_0/m7_nmos_0/a_n1044_n4116# VSUBS nfet_05v0 ad=0.208u pd=4.104m as=0.352u ps=8.176m w=4000 l=400
X106 sh_final_0/opamp_2stage_final_0/m7_nmos_0/a_n556_n8348# sh_final_0/opamp_2stage_final_0/m7_nmos_0/a_n956_n8440# sh_final_0/opamp_2stage_final_0/m7_nmos_0/a_n1044_n8348# VSUBS nfet_05v0 ad=0.208u pd=4.104m as=0.352u ps=8.176m w=4000 l=400
X107 sh_final_0/opamp_2stage_final_0/m7_nmos_0/a_956_n4116# sh_final_0/opamp_2stage_final_0/m7_nmos_0/a_556_n4208# sh_final_0/opamp_2stage_final_0/m7_nmos_0/a_452_n4116# VSUBS nfet_05v0 ad=0.352u pd=8.176m as=0.208u ps=4.104m w=4000 l=400
X108 sh_final_0/opamp_2stage_final_0/m7_nmos_0/a_956_n8348# sh_final_0/opamp_2stage_final_0/m7_nmos_0/a_556_n8440# sh_final_0/opamp_2stage_final_0/m7_nmos_0/a_452_n8348# VSUBS nfet_05v0 ad=0.352u pd=8.176m as=0.208u ps=4.104m w=4000 l=400
X109 sh_final_0/opamp_2stage_final_0/m7_nmos_0/a_452_n4116# sh_final_0/opamp_2stage_final_0/m7_nmos_0/a_52_n4208# sh_final_0/opamp_2stage_final_0/m7_nmos_0/a_n52_n4116# VSUBS nfet_05v0 ad=0.208u pd=4.104m as=0.208u ps=4.104m w=4000 l=400
X110 sh_final_0/opamp_2stage_final_0/m7_nmos_0/a_452_n8348# sh_final_0/opamp_2stage_final_0/m7_nmos_0/a_52_n8440# sh_final_0/opamp_2stage_final_0/m7_nmos_0/a_n52_n8348# VSUBS nfet_05v0 ad=0.208u pd=4.104m as=0.208u ps=4.104m w=4000 l=400
X111 sh_final_0/opamp_2stage_final_0/m7_nmos_0/a_n556_4348# sh_final_0/opamp_2stage_final_0/m7_nmos_0/a_n956_4256# sh_final_0/opamp_2stage_final_0/m7_nmos_0/a_n1044_4348# VSUBS nfet_05v0 ad=0.208u pd=4.104m as=0.352u ps=8.176m w=4000 l=400
X112 sh_final_0/opamp_2stage_final_0/m7_nmos_0/a_n52_116# sh_final_0/opamp_2stage_final_0/m7_nmos_0/a_n452_24# sh_final_0/opamp_2stage_final_0/m7_nmos_0/a_n556_116# VSUBS nfet_05v0 ad=0.208u pd=4.104m as=0.208u ps=4.104m w=4000 l=400
X113 sh_final_0/sw_nmos_0/a_100_n400# sh_final_0/sw_nmos_0/a_n100_n492# sh_final_0/sw_nmos_0/a_n188_n400# VSUBS nfet_05v0 ad=70.4n pd=1.776m as=70.4n ps=1.776m w=800 l=200
X114 sh_final_0/sw_nmos_1/a_100_n400# sh_final_0/sw_nmos_1/a_n100_n492# sh_final_0/sw_nmos_1/a_n188_n400# VSUBS nfet_05v0 ad=70.4n pd=1.776m as=70.4n ps=1.776m w=800 l=200
X115 bias_final_0/bias_nmos_0/a_452_116# bias_final_0/bias_nmos_0/a_52_24# bias_final_0/bias_nmos_0/a_n52_116# VSUBS nfet_05v0 ad=0.1408u pd=3.376m as=83.2n ps=1.704m w=1600 l=400
X116 bias_final_0/bias_nmos_0/a_n52_n1716# bias_final_0/bias_nmos_0/a_n452_n1808# bias_final_0/bias_nmos_0/a_n540_n1716# VSUBS nfet_05v0 ad=83.2n pd=1.704m as=0.1408u ps=3.376m w=1600 l=400
X117 bias_final_0/bias_nmos_0/a_n52_116# bias_final_0/bias_nmos_0/a_n452_24# bias_final_0/bias_nmos_0/a_n540_116# VSUBS nfet_05v0 ad=83.2n pd=1.704m as=0.1408u ps=3.376m w=1600 l=400
X118 bias_final_0/bias_nmos_0/a_452_n1716# bias_final_0/bias_nmos_0/a_52_n1808# bias_final_0/bias_nmos_0/a_n52_n1716# VSUBS nfet_05v0 ad=0.1408u pd=3.376m as=83.2n ps=1.704m w=1600 l=400
X119 bias_final_0/bias_nmos_1/a_452_116# bias_final_0/bias_nmos_1/a_52_24# bias_final_0/bias_nmos_1/a_n52_116# VSUBS nfet_05v0 ad=0.1408u pd=3.376m as=0.1664u ps=3.408m w=1600 l=400
X120 bias_final_0/bias_nmos_1/a_n52_n1716# bias_final_0/bias_nmos_1/a_n452_n1808# bias_final_0/bias_nmos_1/a_n540_n1716# VSUBS nfet_05v0 ad=0.1664u pd=3.408m as=0.1408u ps=3.376m w=1600 l=400
X121 bias_final_0/bias_nmos_1/a_n52_116# bias_final_0/bias_nmos_1/a_n452_24# bias_final_0/bias_nmos_1/a_n540_116# VSUBS nfet_05v0 ad=0 pd=0 as=0.1408u ps=3.376m w=1600 l=400
X122 bias_final_0/bias_nmos_1/a_452_n1716# bias_final_0/bias_nmos_1/a_52_n1808# bias_final_0/bias_nmos_1/a_n52_n1716# VSUBS nfet_05v0 ad=0.1408u pd=3.376m as=0 ps=0 w=1600 l=400
X123 pga_final_0/r_in_0/a_n200_800# pga_final_0/r_in_0/a_n200_n902# VSUBS npolyf_u r_width=400 r_length=1600
X124 pga_final_0/r_fb_0/a_n200_8000# pga_final_0/r_fb_0/a_n200_n8102# VSUBS npolyf_u r_width=400 r_length=16000
X125 pga_final_0/opamp_2stage_final_0/m2_nmos_0/a_n52_4348# pga_final_0/opamp_2stage_final_0/m2_nmos_0/a_n452_4256# pga_final_0/opamp_2stage_final_0/m2_nmos_0/a_n556_4348# VSUBS nfet_05v0 ad=0.416u pd=8.208m as=0.416u ps=8.208m w=4000 l=400
X126 pga_final_0/opamp_2stage_final_0/m2_nmos_0/a_n556_116# pga_final_0/opamp_2stage_final_0/m2_nmos_0/a_n956_24# pga_final_0/opamp_2stage_final_0/m2_nmos_0/a_n1044_116# VSUBS nfet_05v0 ad=0.416u pd=8.208m as=0.352u ps=8.176m w=4000 l=400
X127 pga_final_0/opamp_2stage_final_0/m2_nmos_0/a_n52_n4116# pga_final_0/opamp_2stage_final_0/m2_nmos_0/a_n452_n4208# pga_final_0/opamp_2stage_final_0/m2_nmos_0/a_n556_n4116# VSUBS nfet_05v0 ad=0.416u pd=8.208m as=0.416u ps=8.208m w=4000 l=400
X128 pga_final_0/opamp_2stage_final_0/m2_nmos_0/a_n52_n8348# pga_final_0/opamp_2stage_final_0/m2_nmos_0/a_n452_n8440# pga_final_0/opamp_2stage_final_0/m2_nmos_0/a_n556_n8348# VSUBS nfet_05v0 ad=0.416u pd=8.208m as=0.416u ps=8.208m w=4000 l=400
X129 pga_final_0/opamp_2stage_final_0/m2_nmos_0/a_956_116# pga_final_0/opamp_2stage_final_0/m2_nmos_0/a_556_24# pga_final_0/opamp_2stage_final_0/m2_nmos_0/a_452_116# VSUBS nfet_05v0 ad=0.352u pd=8.176m as=0.416u ps=8.208m w=4000 l=400
X130 pga_final_0/opamp_2stage_final_0/m2_nmos_0/a_452_4348# pga_final_0/opamp_2stage_final_0/m2_nmos_0/a_52_4256# pga_final_0/opamp_2stage_final_0/m2_nmos_0/a_n52_4348# VSUBS nfet_05v0 ad=0.416u pd=8.208m as=0 ps=0 w=4000 l=400
X131 pga_final_0/opamp_2stage_final_0/m2_nmos_0/a_452_116# pga_final_0/opamp_2stage_final_0/m2_nmos_0/a_52_24# pga_final_0/opamp_2stage_final_0/m2_nmos_0/a_n52_116# VSUBS nfet_05v0 ad=0 pd=0 as=0.416u ps=8.208m w=4000 l=400
X132 pga_final_0/opamp_2stage_final_0/m2_nmos_0/a_956_4348# pga_final_0/opamp_2stage_final_0/m2_nmos_0/a_556_4256# pga_final_0/opamp_2stage_final_0/m2_nmos_0/a_452_4348# VSUBS nfet_05v0 ad=0.352u pd=8.176m as=0 ps=0 w=4000 l=400
X133 pga_final_0/opamp_2stage_final_0/m2_nmos_0/a_n556_n4116# pga_final_0/opamp_2stage_final_0/m2_nmos_0/a_n956_n4208# pga_final_0/opamp_2stage_final_0/m2_nmos_0/a_n1044_n4116# VSUBS nfet_05v0 ad=0 pd=0 as=0.352u ps=8.176m w=4000 l=400
X134 pga_final_0/opamp_2stage_final_0/m2_nmos_0/a_n556_n8348# pga_final_0/opamp_2stage_final_0/m2_nmos_0/a_n956_n8440# pga_final_0/opamp_2stage_final_0/m2_nmos_0/a_n1044_n8348# VSUBS nfet_05v0 ad=0 pd=0 as=0.352u ps=8.176m w=4000 l=400
X135 pga_final_0/opamp_2stage_final_0/m2_nmos_0/a_956_n4116# pga_final_0/opamp_2stage_final_0/m2_nmos_0/a_556_n4208# pga_final_0/opamp_2stage_final_0/m2_nmos_0/a_452_n4116# VSUBS nfet_05v0 ad=0.352u pd=8.176m as=0.416u ps=8.208m w=4000 l=400
X136 pga_final_0/opamp_2stage_final_0/m2_nmos_0/a_956_n8348# pga_final_0/opamp_2stage_final_0/m2_nmos_0/a_556_n8440# pga_final_0/opamp_2stage_final_0/m2_nmos_0/a_452_n8348# VSUBS nfet_05v0 ad=0.352u pd=8.176m as=0.416u ps=8.208m w=4000 l=400
X137 pga_final_0/opamp_2stage_final_0/m2_nmos_0/a_452_n4116# pga_final_0/opamp_2stage_final_0/m2_nmos_0/a_52_n4208# pga_final_0/opamp_2stage_final_0/m2_nmos_0/a_n52_n4116# VSUBS nfet_05v0 ad=0 pd=0 as=0 ps=0 w=4000 l=400
X138 pga_final_0/opamp_2stage_final_0/m2_nmos_0/a_452_n8348# pga_final_0/opamp_2stage_final_0/m2_nmos_0/a_52_n8440# pga_final_0/opamp_2stage_final_0/m2_nmos_0/a_n52_n8348# VSUBS nfet_05v0 ad=0 pd=0 as=0 ps=0 w=4000 l=400
X139 pga_final_0/opamp_2stage_final_0/m2_nmos_0/a_n556_4348# pga_final_0/opamp_2stage_final_0/m2_nmos_0/a_n956_4256# pga_final_0/opamp_2stage_final_0/m2_nmos_0/a_n1044_4348# VSUBS nfet_05v0 ad=0 pd=0 as=0.352u ps=8.176m w=4000 l=400
X140 pga_final_0/opamp_2stage_final_0/m2_nmos_0/a_n52_116# pga_final_0/opamp_2stage_final_0/m2_nmos_0/a_n452_24# pga_final_0/opamp_2stage_final_0/m2_nmos_0/a_n556_116# VSUBS nfet_05v0 ad=0 pd=0 as=0 ps=0 w=4000 l=400
X141 pga_final_0/opamp_2stage_final_0/m6_pmos_0/a_n356_116# pga_final_0/opamp_2stage_final_0/m6_pmos_0/a_n556_24# pga_final_0/opamp_2stage_final_0/m6_pmos_0/a_n644_116# VSUBS pfet_05v0 ad=0.832u pd=0.01621 as=0.704u ps=0.01618 w=8000 l=200
X142 VSUBS pga_final_0/opamp_2stage_final_0/m6_pmos_0/a_52_8256# VSUBS VSUBS pfet_05v0 ad=30.08768u pd=0.78083 as=0 ps=0 w=8000 l=200
X143 pga_final_0/opamp_2stage_final_0/m6_pmos_0/a_n52_n8116# pga_final_0/opamp_2stage_final_0/m6_pmos_0/a_n252_n8208# pga_final_0/opamp_2stage_final_0/m6_pmos_0/a_n356_n8116# VSUBS pfet_05v0 ad=0.832u pd=0.01621 as=0.832u ps=0.01621 w=8000 l=200
X144 VSUBS pga_final_0/opamp_2stage_final_0/m6_pmos_0/a_n252_8256# VSUBS VSUBS pfet_05v0 ad=0 pd=0 as=0 ps=0 w=8000 l=200
X145 pga_final_0/opamp_2stage_final_0/m6_pmos_0/a_n52_116# pga_final_0/opamp_2stage_final_0/m6_pmos_0/a_n252_24# pga_final_0/opamp_2stage_final_0/m6_pmos_0/a_n356_116# VSUBS pfet_05v0 ad=0.832u pd=0.01621 as=0 ps=0 w=8000 l=200
X146 pga_final_0/opamp_2stage_final_0/m6_pmos_0/a_252_116# pga_final_0/opamp_2stage_final_0/m6_pmos_0/a_52_24# pga_final_0/opamp_2stage_final_0/m6_pmos_0/a_n52_116# VSUBS pfet_05v0 ad=0.832u pd=0.01621 as=0 ps=0 w=8000 l=200
X147 VSUBS pga_final_0/opamp_2stage_final_0/m6_pmos_0/a_356_n16440# VSUBS VSUBS pfet_05v0 ad=0 pd=0 as=0 ps=0 w=8000 l=200
X148 VSUBS pga_final_0/opamp_2stage_final_0/m6_pmos_0/a_n556_8256# VSUBS VSUBS pfet_05v0 ad=0 pd=0 as=0 ps=0 w=8000 l=200
X149 pga_final_0/opamp_2stage_final_0/m6_pmos_0/a_252_n8116# pga_final_0/opamp_2stage_final_0/m6_pmos_0/a_52_n8208# pga_final_0/opamp_2stage_final_0/m6_pmos_0/a_n52_n8116# VSUBS pfet_05v0 ad=0.832u pd=0.01621 as=0 ps=0 w=8000 l=200
X150 VSUBS pga_final_0/opamp_2stage_final_0/m6_pmos_0/a_52_n16440# VSUBS VSUBS pfet_05v0 ad=0 pd=0 as=0 ps=0 w=8000 l=200
X151 pga_final_0/opamp_2stage_final_0/m6_pmos_0/a_556_n8116# pga_final_0/opamp_2stage_final_0/m6_pmos_0/a_356_n8208# pga_final_0/opamp_2stage_final_0/m6_pmos_0/a_252_n8116# VSUBS pfet_05v0 ad=0.704u pd=0.01618 as=0 ps=0 w=8000 l=200
X152 pga_final_0/opamp_2stage_final_0/m6_pmos_0/a_n356_n8116# pga_final_0/opamp_2stage_final_0/m6_pmos_0/a_n556_n8208# pga_final_0/opamp_2stage_final_0/m6_pmos_0/a_n644_n8116# VSUBS pfet_05v0 ad=0 pd=0 as=0.704u ps=0.01618 w=8000 l=200
X153 VSUBS pga_final_0/opamp_2stage_final_0/m6_pmos_0/a_n556_n16440# VSUBS VSUBS pfet_05v0 ad=0 pd=0 as=0 ps=0 w=8000 l=200
X154 VSUBS pga_final_0/opamp_2stage_final_0/m6_pmos_0/a_356_8256# VSUBS VSUBS pfet_05v0 ad=0 pd=0 as=0 ps=0 w=8000 l=200
X155 pga_final_0/opamp_2stage_final_0/m6_pmos_0/a_556_116# pga_final_0/opamp_2stage_final_0/m6_pmos_0/a_356_24# pga_final_0/opamp_2stage_final_0/m6_pmos_0/a_252_116# VSUBS pfet_05v0 ad=0.704u pd=0.01618 as=0 ps=0 w=8000 l=200
X156 VSUBS pga_final_0/opamp_2stage_final_0/m6_pmos_0/a_n252_n16440# VSUBS VSUBS pfet_05v0 ad=0 pd=0 as=0 ps=0 w=8000 l=200
X157 pga_final_0/opamp_2stage_final_0/m5_nmos_0/a_n52_2348# pga_final_0/opamp_2stage_final_0/m5_nmos_0/a_n452_2256# pga_final_0/opamp_2stage_final_0/m5_nmos_0/a_n556_2348# VSUBS nfet_05v0 ad=0.208u pd=4.208m as=0.208u ps=4.208m w=2000 l=400
X158 pga_final_0/opamp_2stage_final_0/m5_nmos_0/a_n556_116# pga_final_0/opamp_2stage_final_0/m5_nmos_0/a_n956_24# pga_final_0/opamp_2stage_final_0/m5_nmos_0/a_n1044_116# VSUBS nfet_05v0 ad=0.208u pd=4.208m as=0.176u ps=4.176m w=2000 l=400
X159 pga_final_0/opamp_2stage_final_0/m5_nmos_0/a_956_116# pga_final_0/opamp_2stage_final_0/m5_nmos_0/a_556_24# pga_final_0/opamp_2stage_final_0/m5_nmos_0/a_452_116# VSUBS nfet_05v0 ad=0.176u pd=4.176m as=0.208u ps=4.208m w=2000 l=400
X160 pga_final_0/opamp_2stage_final_0/m5_nmos_0/a_n52_n2116# pga_final_0/opamp_2stage_final_0/m5_nmos_0/a_n452_n2208# pga_final_0/opamp_2stage_final_0/m5_nmos_0/a_n556_n2116# VSUBS nfet_05v0 ad=0.208u pd=4.208m as=0.208u ps=4.208m w=2000 l=400
X161 pga_final_0/opamp_2stage_final_0/m5_nmos_0/a_n52_n4348# pga_final_0/opamp_2stage_final_0/m5_nmos_0/a_n452_n4440# pga_final_0/opamp_2stage_final_0/m5_nmos_0/a_n556_n4348# VSUBS nfet_05v0 ad=0.208u pd=4.208m as=0.208u ps=4.208m w=2000 l=400
X162 pga_final_0/opamp_2stage_final_0/m5_nmos_0/a_452_116# pga_final_0/opamp_2stage_final_0/m5_nmos_0/a_52_24# pga_final_0/opamp_2stage_final_0/m5_nmos_0/a_n52_116# VSUBS nfet_05v0 ad=0 pd=0 as=0.208u ps=4.208m w=2000 l=400
X163 pga_final_0/opamp_2stage_final_0/m5_nmos_0/a_452_2348# pga_final_0/opamp_2stage_final_0/m5_nmos_0/a_52_2256# pga_final_0/opamp_2stage_final_0/m5_nmos_0/a_n52_2348# VSUBS nfet_05v0 ad=0.208u pd=4.208m as=0 ps=0 w=2000 l=400
X164 pga_final_0/opamp_2stage_final_0/m5_nmos_0/a_956_2348# pga_final_0/opamp_2stage_final_0/m5_nmos_0/a_556_2256# pga_final_0/opamp_2stage_final_0/m5_nmos_0/a_452_2348# VSUBS nfet_05v0 ad=0.176u pd=4.176m as=0 ps=0 w=2000 l=400
X165 pga_final_0/opamp_2stage_final_0/m5_nmos_0/a_n556_n2116# pga_final_0/opamp_2stage_final_0/m5_nmos_0/a_n956_n2208# pga_final_0/opamp_2stage_final_0/m5_nmos_0/a_n1044_n2116# VSUBS nfet_05v0 ad=0 pd=0 as=0.176u ps=4.176m w=2000 l=400
X166 pga_final_0/opamp_2stage_final_0/m5_nmos_0/a_956_n2116# pga_final_0/opamp_2stage_final_0/m5_nmos_0/a_556_n2208# pga_final_0/opamp_2stage_final_0/m5_nmos_0/a_452_n2116# VSUBS nfet_05v0 ad=0.176u pd=4.176m as=0.208u ps=4.208m w=2000 l=400
X167 pga_final_0/opamp_2stage_final_0/m5_nmos_0/a_n556_n4348# pga_final_0/opamp_2stage_final_0/m5_nmos_0/a_n956_n4440# pga_final_0/opamp_2stage_final_0/m5_nmos_0/a_n1044_n4348# VSUBS nfet_05v0 ad=0 pd=0 as=0.176u ps=4.176m w=2000 l=400
X168 pga_final_0/opamp_2stage_final_0/m5_nmos_0/a_452_n2116# pga_final_0/opamp_2stage_final_0/m5_nmos_0/a_52_n2208# pga_final_0/opamp_2stage_final_0/m5_nmos_0/a_n52_n2116# VSUBS nfet_05v0 ad=0 pd=0 as=0 ps=0 w=2000 l=400
X169 pga_final_0/opamp_2stage_final_0/m5_nmos_0/a_n556_2348# pga_final_0/opamp_2stage_final_0/m5_nmos_0/a_n956_2256# pga_final_0/opamp_2stage_final_0/m5_nmos_0/a_n1044_2348# VSUBS nfet_05v0 ad=0 pd=0 as=0.176u ps=4.176m w=2000 l=400
X170 pga_final_0/opamp_2stage_final_0/m5_nmos_0/a_n52_116# pga_final_0/opamp_2stage_final_0/m5_nmos_0/a_n452_24# pga_final_0/opamp_2stage_final_0/m5_nmos_0/a_n556_116# VSUBS nfet_05v0 ad=0 pd=0 as=0 ps=0 w=2000 l=400
X171 pga_final_0/opamp_2stage_final_0/m5_nmos_0/a_452_n4348# pga_final_0/opamp_2stage_final_0/m5_nmos_0/a_52_n4440# pga_final_0/opamp_2stage_final_0/m5_nmos_0/a_n52_n4348# VSUBS nfet_05v0 ad=0.208u pd=4.208m as=0 ps=0 w=2000 l=400
X172 pga_final_0/opamp_2stage_final_0/m5_nmos_0/a_956_n4348# pga_final_0/opamp_2stage_final_0/m5_nmos_0/a_556_n4440# pga_final_0/opamp_2stage_final_0/m5_nmos_0/a_452_n4348# VSUBS nfet_05v0 ad=0.176u pd=4.176m as=0 ps=0 w=2000 l=400
X173 pga_final_0/opamp_2stage_final_0/m3_pmos_0/a_n556_116# pga_final_0/opamp_2stage_final_0/m3_pmos_0/a_n956_24# pga_final_0/opamp_2stage_final_0/m3_pmos_0/a_n1044_116# pga_final_0/opamp_2stage_final_0/m3_pmos_0/w_n1220_n4604# pfet_05v0 ad=0.208u pd=4.208m as=0.176u ps=4.176m w=2000 l=400
X174 pga_final_0/opamp_2stage_final_0/m3_pmos_0/a_n52_2348# pga_final_0/opamp_2stage_final_0/m3_pmos_0/a_n452_2256# pga_final_0/opamp_2stage_final_0/m3_pmos_0/a_n556_2348# pga_final_0/opamp_2stage_final_0/m3_pmos_0/w_n1220_n4604# pfet_05v0 ad=0.208u pd=4.208m as=0.208u ps=4.208m w=2000 l=400
X175 pga_final_0/opamp_2stage_final_0/m3_pmos_0/a_956_116# pga_final_0/opamp_2stage_final_0/m3_pmos_0/a_556_24# pga_final_0/opamp_2stage_final_0/m3_pmos_0/a_452_116# pga_final_0/opamp_2stage_final_0/m3_pmos_0/w_n1220_n4604# pfet_05v0 ad=0.176u pd=4.176m as=0.208u ps=4.208m w=2000 l=400
X176 pga_final_0/opamp_2stage_final_0/m3_pmos_0/a_n52_n2116# pga_final_0/opamp_2stage_final_0/m3_pmos_0/a_n452_n2208# pga_final_0/opamp_2stage_final_0/m3_pmos_0/a_n556_n2116# pga_final_0/opamp_2stage_final_0/m3_pmos_0/w_n1220_n4604# pfet_05v0 ad=0.208u pd=4.208m as=0.208u ps=4.208m w=2000 l=400
X177 pga_final_0/opamp_2stage_final_0/m3_pmos_0/a_n52_n4348# pga_final_0/opamp_2stage_final_0/m3_pmos_0/a_n452_n4440# pga_final_0/opamp_2stage_final_0/m3_pmos_0/a_n556_n4348# pga_final_0/opamp_2stage_final_0/m3_pmos_0/w_n1220_n4604# pfet_05v0 ad=0.208u pd=4.208m as=0.208u ps=4.208m w=2000 l=400
X178 pga_final_0/opamp_2stage_final_0/m3_pmos_0/a_452_116# pga_final_0/opamp_2stage_final_0/m3_pmos_0/a_52_24# pga_final_0/opamp_2stage_final_0/m3_pmos_0/a_n52_116# pga_final_0/opamp_2stage_final_0/m3_pmos_0/w_n1220_n4604# pfet_05v0 ad=0 pd=0 as=0.208u ps=4.208m w=2000 l=400
X179 pga_final_0/opamp_2stage_final_0/m3_pmos_0/a_452_2348# pga_final_0/opamp_2stage_final_0/m3_pmos_0/a_52_2256# pga_final_0/opamp_2stage_final_0/m3_pmos_0/a_n52_2348# pga_final_0/opamp_2stage_final_0/m3_pmos_0/w_n1220_n4604# pfet_05v0 ad=0.208u pd=4.208m as=0 ps=0 w=2000 l=400
X180 pga_final_0/opamp_2stage_final_0/m3_pmos_0/a_956_2348# pga_final_0/opamp_2stage_final_0/m3_pmos_0/a_556_2256# pga_final_0/opamp_2stage_final_0/m3_pmos_0/a_452_2348# pga_final_0/opamp_2stage_final_0/m3_pmos_0/w_n1220_n4604# pfet_05v0 ad=0.176u pd=4.176m as=0 ps=0 w=2000 l=400
X181 pga_final_0/opamp_2stage_final_0/m3_pmos_0/a_n556_n2116# pga_final_0/opamp_2stage_final_0/m3_pmos_0/a_n956_n2208# pga_final_0/opamp_2stage_final_0/m3_pmos_0/a_n1044_n2116# pga_final_0/opamp_2stage_final_0/m3_pmos_0/w_n1220_n4604# pfet_05v0 ad=0 pd=0 as=0.176u ps=4.176m w=2000 l=400
X182 pga_final_0/opamp_2stage_final_0/m3_pmos_0/a_956_n2116# pga_final_0/opamp_2stage_final_0/m3_pmos_0/a_556_n2208# pga_final_0/opamp_2stage_final_0/m3_pmos_0/a_452_n2116# pga_final_0/opamp_2stage_final_0/m3_pmos_0/w_n1220_n4604# pfet_05v0 ad=0.176u pd=4.176m as=0.208u ps=4.208m w=2000 l=400
X183 pga_final_0/opamp_2stage_final_0/m3_pmos_0/a_n556_n4348# pga_final_0/opamp_2stage_final_0/m3_pmos_0/a_n956_n4440# pga_final_0/opamp_2stage_final_0/m3_pmos_0/a_n1044_n4348# pga_final_0/opamp_2stage_final_0/m3_pmos_0/w_n1220_n4604# pfet_05v0 ad=0 pd=0 as=0.176u ps=4.176m w=2000 l=400
X184 pga_final_0/opamp_2stage_final_0/m3_pmos_0/a_452_n2116# pga_final_0/opamp_2stage_final_0/m3_pmos_0/a_52_n2208# pga_final_0/opamp_2stage_final_0/m3_pmos_0/a_n52_n2116# pga_final_0/opamp_2stage_final_0/m3_pmos_0/w_n1220_n4604# pfet_05v0 ad=0 pd=0 as=0 ps=0 w=2000 l=400
X185 pga_final_0/opamp_2stage_final_0/m3_pmos_0/a_n556_2348# pga_final_0/opamp_2stage_final_0/m3_pmos_0/a_n956_2256# pga_final_0/opamp_2stage_final_0/m3_pmos_0/a_n1044_2348# pga_final_0/opamp_2stage_final_0/m3_pmos_0/w_n1220_n4604# pfet_05v0 ad=0 pd=0 as=0.176u ps=4.176m w=2000 l=400
X186 pga_final_0/opamp_2stage_final_0/m3_pmos_0/a_n52_116# pga_final_0/opamp_2stage_final_0/m3_pmos_0/a_n452_24# pga_final_0/opamp_2stage_final_0/m3_pmos_0/a_n556_116# pga_final_0/opamp_2stage_final_0/m3_pmos_0/w_n1220_n4604# pfet_05v0 ad=0 pd=0 as=0 ps=0 w=2000 l=400
X187 pga_final_0/opamp_2stage_final_0/m3_pmos_0/a_452_n4348# pga_final_0/opamp_2stage_final_0/m3_pmos_0/a_52_n4440# pga_final_0/opamp_2stage_final_0/m3_pmos_0/a_n52_n4348# pga_final_0/opamp_2stage_final_0/m3_pmos_0/w_n1220_n4604# pfet_05v0 ad=0.208u pd=4.208m as=0 ps=0 w=2000 l=400
X188 pga_final_0/opamp_2stage_final_0/m3_pmos_0/a_956_n4348# pga_final_0/opamp_2stage_final_0/m3_pmos_0/a_556_n4440# pga_final_0/opamp_2stage_final_0/m3_pmos_0/a_452_n4348# pga_final_0/opamp_2stage_final_0/m3_pmos_0/w_n1220_n4604# pfet_05v0 ad=0.176u pd=4.176m as=0 ps=0 w=2000 l=400
X189 pga_final_0/opamp_2stage_final_0/m4_pmos_0/a_n556_116# pga_final_0/opamp_2stage_final_0/m4_pmos_0/a_n956_24# pga_final_0/opamp_2stage_final_0/m4_pmos_0/a_n1044_116# pga_final_0/opamp_2stage_final_0/m4_pmos_0/w_n1220_n4604# pfet_05v0 ad=0.208u pd=4.208m as=0.176u ps=4.176m w=2000 l=400
X190 pga_final_0/opamp_2stage_final_0/m4_pmos_0/a_n52_2348# pga_final_0/opamp_2stage_final_0/m4_pmos_0/a_n452_2256# pga_final_0/opamp_2stage_final_0/m4_pmos_0/a_n556_2348# pga_final_0/opamp_2stage_final_0/m4_pmos_0/w_n1220_n4604# pfet_05v0 ad=0.208u pd=4.208m as=0.208u ps=4.208m w=2000 l=400
X191 pga_final_0/opamp_2stage_final_0/m4_pmos_0/a_956_116# pga_final_0/opamp_2stage_final_0/m4_pmos_0/a_556_24# pga_final_0/opamp_2stage_final_0/m4_pmos_0/a_452_116# pga_final_0/opamp_2stage_final_0/m4_pmos_0/w_n1220_n4604# pfet_05v0 ad=0.176u pd=4.176m as=0.208u ps=4.208m w=2000 l=400
X192 pga_final_0/opamp_2stage_final_0/m4_pmos_0/a_n52_n2116# pga_final_0/opamp_2stage_final_0/m4_pmos_0/a_n452_n2208# pga_final_0/opamp_2stage_final_0/m4_pmos_0/a_n556_n2116# pga_final_0/opamp_2stage_final_0/m4_pmos_0/w_n1220_n4604# pfet_05v0 ad=0.208u pd=4.208m as=0.208u ps=4.208m w=2000 l=400
X193 pga_final_0/opamp_2stage_final_0/m4_pmos_0/a_n52_n4348# pga_final_0/opamp_2stage_final_0/m4_pmos_0/a_n452_n4440# pga_final_0/opamp_2stage_final_0/m4_pmos_0/a_n556_n4348# pga_final_0/opamp_2stage_final_0/m4_pmos_0/w_n1220_n4604# pfet_05v0 ad=0.208u pd=4.208m as=0.208u ps=4.208m w=2000 l=400
X194 pga_final_0/opamp_2stage_final_0/m4_pmos_0/a_452_116# pga_final_0/opamp_2stage_final_0/m4_pmos_0/a_52_24# pga_final_0/opamp_2stage_final_0/m4_pmos_0/a_n52_116# pga_final_0/opamp_2stage_final_0/m4_pmos_0/w_n1220_n4604# pfet_05v0 ad=0 pd=0 as=0.208u ps=4.208m w=2000 l=400
X195 pga_final_0/opamp_2stage_final_0/m4_pmos_0/a_452_2348# pga_final_0/opamp_2stage_final_0/m4_pmos_0/a_52_2256# pga_final_0/opamp_2stage_final_0/m4_pmos_0/a_n52_2348# pga_final_0/opamp_2stage_final_0/m4_pmos_0/w_n1220_n4604# pfet_05v0 ad=0.208u pd=4.208m as=0 ps=0 w=2000 l=400
X196 pga_final_0/opamp_2stage_final_0/m4_pmos_0/a_956_2348# pga_final_0/opamp_2stage_final_0/m4_pmos_0/a_556_2256# pga_final_0/opamp_2stage_final_0/m4_pmos_0/a_452_2348# pga_final_0/opamp_2stage_final_0/m4_pmos_0/w_n1220_n4604# pfet_05v0 ad=0.176u pd=4.176m as=0 ps=0 w=2000 l=400
X197 pga_final_0/opamp_2stage_final_0/m4_pmos_0/a_n556_n2116# pga_final_0/opamp_2stage_final_0/m4_pmos_0/a_n956_n2208# pga_final_0/opamp_2stage_final_0/m4_pmos_0/a_n1044_n2116# pga_final_0/opamp_2stage_final_0/m4_pmos_0/w_n1220_n4604# pfet_05v0 ad=0 pd=0 as=0.176u ps=4.176m w=2000 l=400
X198 pga_final_0/opamp_2stage_final_0/m4_pmos_0/a_956_n2116# pga_final_0/opamp_2stage_final_0/m4_pmos_0/a_556_n2208# pga_final_0/opamp_2stage_final_0/m4_pmos_0/a_452_n2116# pga_final_0/opamp_2stage_final_0/m4_pmos_0/w_n1220_n4604# pfet_05v0 ad=0.176u pd=4.176m as=0.208u ps=4.208m w=2000 l=400
X199 pga_final_0/opamp_2stage_final_0/m4_pmos_0/a_n556_n4348# pga_final_0/opamp_2stage_final_0/m4_pmos_0/a_n956_n4440# pga_final_0/opamp_2stage_final_0/m4_pmos_0/a_n1044_n4348# pga_final_0/opamp_2stage_final_0/m4_pmos_0/w_n1220_n4604# pfet_05v0 ad=0 pd=0 as=0.176u ps=4.176m w=2000 l=400
X200 pga_final_0/opamp_2stage_final_0/m4_pmos_0/a_452_n2116# pga_final_0/opamp_2stage_final_0/m4_pmos_0/a_52_n2208# pga_final_0/opamp_2stage_final_0/m4_pmos_0/a_n52_n2116# pga_final_0/opamp_2stage_final_0/m4_pmos_0/w_n1220_n4604# pfet_05v0 ad=0 pd=0 as=0 ps=0 w=2000 l=400
X201 pga_final_0/opamp_2stage_final_0/m4_pmos_0/a_n556_2348# pga_final_0/opamp_2stage_final_0/m4_pmos_0/a_n956_2256# pga_final_0/opamp_2stage_final_0/m4_pmos_0/a_n1044_2348# pga_final_0/opamp_2stage_final_0/m4_pmos_0/w_n1220_n4604# pfet_05v0 ad=0 pd=0 as=0.176u ps=4.176m w=2000 l=400
X202 pga_final_0/opamp_2stage_final_0/m4_pmos_0/a_n52_116# pga_final_0/opamp_2stage_final_0/m4_pmos_0/a_n452_24# pga_final_0/opamp_2stage_final_0/m4_pmos_0/a_n556_116# pga_final_0/opamp_2stage_final_0/m4_pmos_0/w_n1220_n4604# pfet_05v0 ad=0 pd=0 as=0 ps=0 w=2000 l=400
X203 pga_final_0/opamp_2stage_final_0/m4_pmos_0/a_452_n4348# pga_final_0/opamp_2stage_final_0/m4_pmos_0/a_52_n4440# pga_final_0/opamp_2stage_final_0/m4_pmos_0/a_n52_n4348# pga_final_0/opamp_2stage_final_0/m4_pmos_0/w_n1220_n4604# pfet_05v0 ad=0.208u pd=4.208m as=0 ps=0 w=2000 l=400
X204 pga_final_0/opamp_2stage_final_0/m4_pmos_0/a_956_n4348# pga_final_0/opamp_2stage_final_0/m4_pmos_0/a_556_n4440# pga_final_0/opamp_2stage_final_0/m4_pmos_0/a_452_n4348# pga_final_0/opamp_2stage_final_0/m4_pmos_0/w_n1220_n4604# pfet_05v0 ad=0.176u pd=4.176m as=0 ps=0 w=2000 l=400
X205 pga_final_0/opamp_2stage_final_0/m1_nmos_0/a_n52_4348# pga_final_0/opamp_2stage_final_0/m1_nmos_0/a_n452_4256# pga_final_0/opamp_2stage_final_0/m1_nmos_0/a_n556_4348# VSUBS nfet_05v0 ad=0.416u pd=8.208m as=0.416u ps=8.208m w=4000 l=400
X206 pga_final_0/opamp_2stage_final_0/m1_nmos_0/a_n556_116# pga_final_0/opamp_2stage_final_0/m1_nmos_0/a_n956_24# pga_final_0/opamp_2stage_final_0/m1_nmos_0/a_n1044_116# VSUBS nfet_05v0 ad=0.416u pd=8.208m as=0.352u ps=8.176m w=4000 l=400
X207 pga_final_0/opamp_2stage_final_0/m1_nmos_0/a_n52_n4116# pga_final_0/opamp_2stage_final_0/m1_nmos_0/a_n452_n4208# pga_final_0/opamp_2stage_final_0/m1_nmos_0/a_n556_n4116# VSUBS nfet_05v0 ad=0.416u pd=8.208m as=0.416u ps=8.208m w=4000 l=400
X208 pga_final_0/opamp_2stage_final_0/m1_nmos_0/a_n52_n8348# pga_final_0/opamp_2stage_final_0/m1_nmos_0/a_n452_n8440# pga_final_0/opamp_2stage_final_0/m1_nmos_0/a_n556_n8348# VSUBS nfet_05v0 ad=0.416u pd=8.208m as=0.416u ps=8.208m w=4000 l=400
X209 pga_final_0/opamp_2stage_final_0/m1_nmos_0/a_956_116# pga_final_0/opamp_2stage_final_0/m1_nmos_0/a_556_24# pga_final_0/opamp_2stage_final_0/m1_nmos_0/a_452_116# VSUBS nfet_05v0 ad=0.352u pd=8.176m as=0.416u ps=8.208m w=4000 l=400
X210 pga_final_0/opamp_2stage_final_0/m1_nmos_0/a_452_4348# pga_final_0/opamp_2stage_final_0/m1_nmos_0/a_52_4256# pga_final_0/opamp_2stage_final_0/m1_nmos_0/a_n52_4348# VSUBS nfet_05v0 ad=0.416u pd=8.208m as=0 ps=0 w=4000 l=400
X211 pga_final_0/opamp_2stage_final_0/m1_nmos_0/a_452_116# pga_final_0/opamp_2stage_final_0/m1_nmos_0/a_52_24# pga_final_0/opamp_2stage_final_0/m1_nmos_0/a_n52_116# VSUBS nfet_05v0 ad=0 pd=0 as=0.416u ps=8.208m w=4000 l=400
X212 pga_final_0/opamp_2stage_final_0/m1_nmos_0/a_956_4348# pga_final_0/opamp_2stage_final_0/m1_nmos_0/a_556_4256# pga_final_0/opamp_2stage_final_0/m1_nmos_0/a_452_4348# VSUBS nfet_05v0 ad=0.352u pd=8.176m as=0 ps=0 w=4000 l=400
X213 pga_final_0/opamp_2stage_final_0/m1_nmos_0/a_n556_n4116# pga_final_0/opamp_2stage_final_0/m1_nmos_0/a_n956_n4208# pga_final_0/opamp_2stage_final_0/m1_nmos_0/a_n1044_n4116# VSUBS nfet_05v0 ad=0 pd=0 as=0.352u ps=8.176m w=4000 l=400
X214 pga_final_0/opamp_2stage_final_0/m1_nmos_0/a_n556_n8348# pga_final_0/opamp_2stage_final_0/m1_nmos_0/a_n956_n8440# pga_final_0/opamp_2stage_final_0/m1_nmos_0/a_n1044_n8348# VSUBS nfet_05v0 ad=0 pd=0 as=0.352u ps=8.176m w=4000 l=400
X215 pga_final_0/opamp_2stage_final_0/m1_nmos_0/a_956_n4116# pga_final_0/opamp_2stage_final_0/m1_nmos_0/a_556_n4208# pga_final_0/opamp_2stage_final_0/m1_nmos_0/a_452_n4116# VSUBS nfet_05v0 ad=0.352u pd=8.176m as=0.416u ps=8.208m w=4000 l=400
X216 pga_final_0/opamp_2stage_final_0/m1_nmos_0/a_956_n8348# pga_final_0/opamp_2stage_final_0/m1_nmos_0/a_556_n8440# pga_final_0/opamp_2stage_final_0/m1_nmos_0/a_452_n8348# VSUBS nfet_05v0 ad=0.352u pd=8.176m as=0.416u ps=8.208m w=4000 l=400
X217 pga_final_0/opamp_2stage_final_0/m1_nmos_0/a_452_n4116# pga_final_0/opamp_2stage_final_0/m1_nmos_0/a_52_n4208# pga_final_0/opamp_2stage_final_0/m1_nmos_0/a_n52_n4116# VSUBS nfet_05v0 ad=0 pd=0 as=0 ps=0 w=4000 l=400
X218 pga_final_0/opamp_2stage_final_0/m1_nmos_0/a_452_n8348# pga_final_0/opamp_2stage_final_0/m1_nmos_0/a_52_n8440# pga_final_0/opamp_2stage_final_0/m1_nmos_0/a_n52_n8348# VSUBS nfet_05v0 ad=0 pd=0 as=0 ps=0 w=4000 l=400
X219 pga_final_0/opamp_2stage_final_0/m1_nmos_0/a_n556_4348# pga_final_0/opamp_2stage_final_0/m1_nmos_0/a_n956_4256# pga_final_0/opamp_2stage_final_0/m1_nmos_0/a_n1044_4348# VSUBS nfet_05v0 ad=0 pd=0 as=0.352u ps=8.176m w=4000 l=400
X220 pga_final_0/opamp_2stage_final_0/m1_nmos_0/a_n52_116# pga_final_0/opamp_2stage_final_0/m1_nmos_0/a_n452_24# pga_final_0/opamp_2stage_final_0/m1_nmos_0/a_n556_116# VSUBS nfet_05v0 ad=0 pd=0 as=0 ps=0 w=4000 l=400
X221 pga_final_0/opamp_2stage_final_0/m7_nmos_0/a_n52_4348# pga_final_0/opamp_2stage_final_0/m7_nmos_0/a_n452_4256# pga_final_0/opamp_2stage_final_0/m7_nmos_0/a_n556_4348# VSUBS nfet_05v0 ad=0.416u pd=8.208m as=0.416u ps=8.208m w=4000 l=400
X222 pga_final_0/opamp_2stage_final_0/m7_nmos_0/a_n556_116# pga_final_0/opamp_2stage_final_0/m7_nmos_0/a_n956_24# pga_final_0/opamp_2stage_final_0/m7_nmos_0/a_n1044_116# VSUBS nfet_05v0 ad=0.416u pd=8.208m as=0.352u ps=8.176m w=4000 l=400
X223 pga_final_0/opamp_2stage_final_0/m7_nmos_0/a_n52_n4116# pga_final_0/opamp_2stage_final_0/m7_nmos_0/a_n452_n4208# pga_final_0/opamp_2stage_final_0/m7_nmos_0/a_n556_n4116# VSUBS nfet_05v0 ad=0.416u pd=8.208m as=0.416u ps=8.208m w=4000 l=400
X224 pga_final_0/opamp_2stage_final_0/m7_nmos_0/a_n52_n8348# pga_final_0/opamp_2stage_final_0/m7_nmos_0/a_n452_n8440# pga_final_0/opamp_2stage_final_0/m7_nmos_0/a_n556_n8348# VSUBS nfet_05v0 ad=0.416u pd=8.208m as=0.416u ps=8.208m w=4000 l=400
X225 pga_final_0/opamp_2stage_final_0/m7_nmos_0/a_956_116# pga_final_0/opamp_2stage_final_0/m7_nmos_0/a_556_24# pga_final_0/opamp_2stage_final_0/m7_nmos_0/a_452_116# VSUBS nfet_05v0 ad=0.352u pd=8.176m as=0.416u ps=8.208m w=4000 l=400
X226 pga_final_0/opamp_2stage_final_0/m7_nmos_0/a_452_4348# pga_final_0/opamp_2stage_final_0/m7_nmos_0/a_52_4256# pga_final_0/opamp_2stage_final_0/m7_nmos_0/a_n52_4348# VSUBS nfet_05v0 ad=0.416u pd=8.208m as=0 ps=0 w=4000 l=400
X227 pga_final_0/opamp_2stage_final_0/m7_nmos_0/a_452_116# pga_final_0/opamp_2stage_final_0/m7_nmos_0/a_52_24# pga_final_0/opamp_2stage_final_0/m7_nmos_0/a_n52_116# VSUBS nfet_05v0 ad=0 pd=0 as=0.416u ps=8.208m w=4000 l=400
X228 pga_final_0/opamp_2stage_final_0/m7_nmos_0/a_956_4348# pga_final_0/opamp_2stage_final_0/m7_nmos_0/a_556_4256# pga_final_0/opamp_2stage_final_0/m7_nmos_0/a_452_4348# VSUBS nfet_05v0 ad=0.352u pd=8.176m as=0 ps=0 w=4000 l=400
X229 pga_final_0/opamp_2stage_final_0/m7_nmos_0/a_n556_n4116# pga_final_0/opamp_2stage_final_0/m7_nmos_0/a_n956_n4208# pga_final_0/opamp_2stage_final_0/m7_nmos_0/a_n1044_n4116# VSUBS nfet_05v0 ad=0 pd=0 as=0.352u ps=8.176m w=4000 l=400
X230 pga_final_0/opamp_2stage_final_0/m7_nmos_0/a_n556_n8348# pga_final_0/opamp_2stage_final_0/m7_nmos_0/a_n956_n8440# pga_final_0/opamp_2stage_final_0/m7_nmos_0/a_n1044_n8348# VSUBS nfet_05v0 ad=0 pd=0 as=0.352u ps=8.176m w=4000 l=400
X231 pga_final_0/opamp_2stage_final_0/m7_nmos_0/a_956_n4116# pga_final_0/opamp_2stage_final_0/m7_nmos_0/a_556_n4208# pga_final_0/opamp_2stage_final_0/m7_nmos_0/a_452_n4116# VSUBS nfet_05v0 ad=0.352u pd=8.176m as=0.416u ps=8.208m w=4000 l=400
X232 pga_final_0/opamp_2stage_final_0/m7_nmos_0/a_956_n8348# pga_final_0/opamp_2stage_final_0/m7_nmos_0/a_556_n8440# pga_final_0/opamp_2stage_final_0/m7_nmos_0/a_452_n8348# VSUBS nfet_05v0 ad=0.352u pd=8.176m as=0.416u ps=8.208m w=4000 l=400
X233 pga_final_0/opamp_2stage_final_0/m7_nmos_0/a_452_n4116# pga_final_0/opamp_2stage_final_0/m7_nmos_0/a_52_n4208# pga_final_0/opamp_2stage_final_0/m7_nmos_0/a_n52_n4116# VSUBS nfet_05v0 ad=0 pd=0 as=0 ps=0 w=4000 l=400
X234 pga_final_0/opamp_2stage_final_0/m7_nmos_0/a_452_n8348# pga_final_0/opamp_2stage_final_0/m7_nmos_0/a_52_n8440# pga_final_0/opamp_2stage_final_0/m7_nmos_0/a_n52_n8348# VSUBS nfet_05v0 ad=0 pd=0 as=0 ps=0 w=4000 l=400
X235 pga_final_0/opamp_2stage_final_0/m7_nmos_0/a_n556_4348# pga_final_0/opamp_2stage_final_0/m7_nmos_0/a_n956_4256# pga_final_0/opamp_2stage_final_0/m7_nmos_0/a_n1044_4348# VSUBS nfet_05v0 ad=0 pd=0 as=0.352u ps=8.176m w=4000 l=400
X236 pga_final_0/opamp_2stage_final_0/m7_nmos_0/a_n52_116# pga_final_0/opamp_2stage_final_0/m7_nmos_0/a_n452_24# pga_final_0/opamp_2stage_final_0/m7_nmos_0/a_n556_116# VSUBS nfet_05v0 ad=0 pd=0 as=0 ps=0 w=4000 l=400
X237 vref_final_0/r_vref_0/a_n200_1800# vref_final_0/r_vref_0/a_n200_n1902# VSUBS npolyf_u r_width=400 r_length=3600
X238 vref_final_0/r_vref_1/a_n200_1800# vref_final_0/r_vref_1/a_n200_n1902# VSUBS npolyf_u r_width=400 r_length=3600
X239 vref_final_0/r_vref_2/a_n200_1800# vref_final_0/r_vref_2/a_n200_n1902# VSUBS npolyf_u r_width=400 r_length=3600
X240 vref_final_0/vref_nmos_0/a_400_n200# vref_final_0/vref_nmos_0/a_n400_n292# vref_final_0/vref_nmos_0/a_n488_n200# VSUBS nfet_05v0 ad=35.2n pd=0.976m as=35.2n ps=0.976m w=400 l=800
C0 pga_final_0/opamp_2stage_final_0/m2_nmos_0/a_n956_24# pga_final_0/opamp_2stage_final_0/m2_nmos_0/a_n956_n4208# 0.37451f
C1 pga_final_0/opamp_2stage_final_0/m3_pmos_0/a_n52_n2116# pga_final_0/opamp_2stage_final_0/m3_pmos_0/a_n452_n2208# 0.29587f
C2 bias_final_0/bias_nmos_1/a_52_24# bias_final_0/m2_n100_6000# 0.20206f
C3 sh_final_0/opamp_2stage_final_0/m4_pmos_0/a_52_n2208# sh_final_0/opamp_2stage_final_0/m4_pmos_0/a_52_24# 0.37451f
C4 sh_final_0/opamp_2stage_final_0/m2_nmos_0/a_452_4348# sh_final_0/opamp_2stage_final_0/m2_nmos_0/a_n52_4348# 0.39251f
C5 pga_final_0/opamp_2stage_final_0/m3_pmos_0/w_n1220_n4604# pga_final_0/opamp_2stage_final_0/m3_pmos_0/a_956_2348# 1.26104f
C6 pga_final_0/opamp_2stage_final_0/m7_nmos_0/a_n956_4256# pga_final_0/opamp_2stage_final_0/m7_nmos_0/a_n556_4348# 0.59234f
C7 pga_final_0/opamp_2stage_final_0/m3_pmos_0/w_n1220_n4604# pga_final_0/opamp_2stage_final_0/m3_pmos_0/a_452_2348# 0.47456f
C8 sh_final_0/opamp_2stage_final_0/m3_pmos_0/a_n956_2256# sh_final_0/opamp_2stage_final_0/m3_pmos_0/w_n1220_n4604# 0.76217f
C9 pga_final_0/opamp_2stage_final_0/m2_nmos_0/a_52_24# pga_final_0/opamp_2stage_final_0/m2_nmos_0/a_n52_116# 0.59234f
C10 pga_final_0/opamp_2stage_final_0/m1_nmos_0/a_n1044_n4116# pga_final_0/opamp_2stage_final_0/m1_nmos_0/a_n956_n4208# 0.59234f
C11 pga_final_0/opamp_2stage_final_0/m6_pmos_0/a_n356_n8116# pga_final_0/opamp_2stage_final_0/m6_pmos_0/a_n644_n8116# 1.43738f
C12 pga_final_0/opamp_2stage_final_0/m6_pmos_0/a_52_n16440# pga_final_0/opamp_2stage_final_0/m6_pmos_0/a_52_n8208# 0.18596f
C13 pga_final_0/opamp_2stage_final_0/m3_pmos_0/a_556_n4440# pga_final_0/opamp_2stage_final_0/m3_pmos_0/a_956_n4348# 0.29587f
C14 sh_final_0/opamp_2stage_final_0/m5_nmos_0/a_n556_2348# sh_final_0/opamp_2stage_final_0/m5_nmos_0/a_n452_2256# 0.29587f
C15 sh_final_0/opamp_2stage_final_0/m6_pmos_0/a_n644_116# sh_final_0/opamp_2stage_final_0/m6_pmos_0/a_n556_24# 0.85436f
C16 pga_final_0/opamp_2stage_final_0/m4_pmos_0/a_956_2348# pga_final_0/opamp_2stage_final_0/m4_pmos_0/a_452_2348# 0.19606f
C17 sh_final_0/opamp_2stage_final_0/m7_nmos_0/a_n556_n4116# sh_final_0/opamp_2stage_final_0/m7_nmos_0/a_n52_n4116# 0.39251f
C18 pga_final_0/opamp_2stage_final_0/m1_nmos_0/a_n452_n8440# pga_final_0/opamp_2stage_final_0/m1_nmos_0/a_n52_n8348# 0.59234f
C19 pga_final_0/opamp_2stage_final_0/m4_pmos_0/a_n956_n4440# pga_final_0/opamp_2stage_final_0/m4_pmos_0/a_n956_n2208# 0.37451f
C20 sh_final_0/opamp_2stage_final_0/m6_pmos_0/a_n556_n8208# sh_final_0/opamp_2stage_final_0/m6_pmos_0/a_n556_n16440# 0.18596f
C21 sh_final_0/opamp_2stage_final_0/m5_nmos_0/a_n956_2256# sh_final_0/opamp_2stage_final_0/m5_nmos_0/a_n956_24# 0.37451f
C22 sh_final_0/opamp_2stage_final_0/m5_nmos_0/a_n452_n2208# sh_final_0/opamp_2stage_final_0/m5_nmos_0/a_n556_n2116# 0.29587f
C23 pga_final_0/opamp_2stage_final_0/m4_pmos_0/a_52_n2208# pga_final_0/opamp_2stage_final_0/m4_pmos_0/a_556_n2208# 0.05997f
C24 pga_final_0/opamp_2stage_final_0/m5_nmos_0/a_n452_n2208# pga_final_0/opamp_2stage_final_0/m5_nmos_0/a_n956_n2208# 0.05997f
C25 pga_final_0/opamp_2stage_final_0/m6_pmos_0/a_n52_116# pga_final_0/opamp_2stage_final_0/m6_pmos_0/a_n356_116# 1.43738f
C26 pga_final_0/opamp_2stage_final_0/m6_pmos_0/a_556_116# pga_final_0/opamp_2stage_final_0/m6_pmos_0/a_356_24# 0.85436f
C27 pga_final_0/opamp_2stage_final_0/m6_pmos_0/a_n252_n8208# pga_final_0/opamp_2stage_final_0/m6_pmos_0/a_n252_24# 0.18596f
C28 sh_final_0/opamp_2stage_final_0/m3_pmos_0/a_n556_n4348# sh_final_0/opamp_2stage_final_0/m3_pmos_0/a_n52_n4348# 0.19606f
C29 sh_final_0/opamp_2stage_final_0/m5_nmos_0/a_n52_n4348# sh_final_0/opamp_2stage_final_0/m5_nmos_0/a_52_n4440# 0.29587f
C30 sh_final_0/opamp_2stage_final_0/m6_pmos_0/a_n52_116# sh_final_0/opamp_2stage_final_0/m6_pmos_0/a_n252_24# 0.85436f
C31 pga_final_0/opamp_2stage_final_0/m7_nmos_0/a_n452_n4208# pga_final_0/opamp_2stage_final_0/m7_nmos_0/a_n556_n4116# 0.59234f
C32 pga_final_0/opamp_2stage_final_0/m5_nmos_0/a_956_116# pga_final_0/opamp_2stage_final_0/m5_nmos_0/a_452_116# 0.19606f
C33 sh_final_0/opamp_2stage_final_0/m2_nmos_0/a_52_n4208# sh_final_0/opamp_2stage_final_0/m2_nmos_0/a_452_n4116# 0.59234f
C34 pga_final_0/opamp_2stage_final_0/m7_nmos_0/a_52_n8440# pga_final_0/opamp_2stage_final_0/m7_nmos_0/a_556_n8440# 0.05997f
C35 sh_final_0/opamp_2stage_final_0/m1_nmos_0/a_52_24# sh_final_0/opamp_2stage_final_0/m1_nmos_0/a_n452_24# 0.05997f
C36 sh_final_0/opamp_2stage_final_0/m7_nmos_0/a_n1044_116# sh_final_0/opamp_2stage_final_0/m7_nmos_0/a_n956_24# 0.59234f
C37 sh_final_0/opamp_2stage_final_0/m2_nmos_0/a_n556_116# sh_final_0/opamp_2stage_final_0/m2_nmos_0/a_n452_24# 0.59234f
C38 pga_final_0/opamp_2stage_final_0/m4_pmos_0/a_n452_24# pga_final_0/opamp_2stage_final_0/m4_pmos_0/a_n452_n2208# 0.37451f
C39 sh_final_0/opamp_2stage_final_0/m3_pmos_0/a_n452_n2208# sh_final_0/opamp_2stage_final_0/m3_pmos_0/w_n1220_n4604# 0.45835f
C40 sh_final_0/opamp_2stage_final_0/m2_nmos_0/a_452_n8348# sh_final_0/opamp_2stage_final_0/m2_nmos_0/a_556_n8440# 0.59234f
C41 pga_final_0/opamp_2stage_final_0/m2_nmos_0/a_n1044_n8348# pga_final_0/opamp_2stage_final_0/m2_nmos_0/a_n956_n8440# 0.59234f
C42 sh_final_0/opamp_2stage_final_0/m5_nmos_0/a_956_n4348# sh_final_0/opamp_2stage_final_0/m5_nmos_0/a_556_n4440# 0.29587f
C43 pga_final_0/opamp_2stage_final_0/m1_nmos_0/a_n956_n4208# pga_final_0/opamp_2stage_final_0/m1_nmos_0/a_n452_n4208# 0.05997f
C44 sh_final_0/opamp_2stage_final_0/m4_pmos_0/a_n956_2256# sh_final_0/opamp_2stage_final_0/m4_pmos_0/w_n1220_n4604# 0.76217f
C45 pga_final_0/opamp_2stage_final_0/m4_pmos_0/a_452_2348# pga_final_0/opamp_2stage_final_0/m4_pmos_0/a_556_2256# 0.29587f
C46 sh_final_0/opamp_2stage_final_0/m1_nmos_0/a_n52_n4116# sh_final_0/opamp_2stage_final_0/m1_nmos_0/a_n452_n4208# 0.59234f
C47 sh_final_0/opamp_2stage_final_0/m5_nmos_0/a_452_116# sh_final_0/opamp_2stage_final_0/m5_nmos_0/a_956_116# 0.19606f
C48 pga_final_0/opamp_2stage_final_0/m4_pmos_0/w_n1220_n4604# pga_final_0/opamp_2stage_final_0/m4_pmos_0/a_n452_24# 0.45835f
C49 pga_final_0/opamp_2stage_final_0/m7_nmos_0/a_n556_4348# pga_final_0/opamp_2stage_final_0/m7_nmos_0/a_n52_4348# 0.39251f
C50 pga_final_0/opamp_2stage_final_0/m7_nmos_0/a_52_n8440# pga_final_0/opamp_2stage_final_0/m7_nmos_0/a_52_n4208# 0.37451f
C51 sh_final_0/opamp_2stage_final_0/m7_nmos_0/a_n956_24# sh_final_0/opamp_2stage_final_0/m7_nmos_0/a_n452_24# 0.05997f
C52 sh_final_0/opamp_2stage_final_0/m5_nmos_0/a_556_n2208# sh_final_0/opamp_2stage_final_0/m5_nmos_0/a_452_n2116# 0.29587f
C53 pga_final_0/opamp_2stage_final_0/m4_pmos_0/a_n556_116# pga_final_0/opamp_2stage_final_0/m4_pmos_0/a_n452_24# 0.29587f
C54 pga_final_0/opamp_2stage_final_0/m3_pmos_0/w_n1220_n4604# pga_final_0/opamp_2stage_final_0/m3_pmos_0/a_n556_n4348# 0.47456f
C55 pga_final_0/opamp_2stage_final_0/m5_nmos_0/a_n52_2348# pga_final_0/opamp_2stage_final_0/m5_nmos_0/a_52_2256# 0.29587f
C56 pga_final_0/opamp_2stage_final_0/m5_nmos_0/a_n556_2348# pga_final_0/opamp_2stage_final_0/m5_nmos_0/a_n1044_2348# 0.19606f
C57 sh_final_0/c_samp_0/m4_n3120_n3000# sh_final_0/c_samp_0/m4_n3240_n3120# 4.0879f
C58 sh_final_0/opamp_2stage_final_0/m7_nmos_0/a_n452_4256# sh_final_0/opamp_2stage_final_0/m7_nmos_0/a_n956_4256# 0.05997f
C59 sh_final_0/opamp_2stage_final_0/m1_nmos_0/a_452_n8348# sh_final_0/opamp_2stage_final_0/m1_nmos_0/a_956_n8348# 0.39251f
C60 sh_final_0/opamp_2stage_final_0/m5_nmos_0/a_n452_24# sh_final_0/opamp_2stage_final_0/m5_nmos_0/a_n52_116# 0.29587f
C61 sh_final_0/opamp_2stage_final_0/m5_nmos_0/a_52_24# sh_final_0/opamp_2stage_final_0/m5_nmos_0/a_n452_24# 0.05997f
C62 bias_final_0/bias_nmos_0/a_52_n1808# bias_final_0/bias_nmos_0/a_452_n1716# 0.23658f
C63 sh_final_0/opamp_2stage_final_0/m1_n2152_32500# sh_final_0/c_samp_0/m4_n3120_n3000# 1.35296f
C64 sh_final_0/opamp_2stage_final_0/m1_nmos_0/a_n452_n4208# sh_final_0/opamp_2stage_final_0/m1_nmos_0/a_n452_24# 0.37451f
C65 pga_final_0/opamp_2stage_final_0/m3_pmos_0/a_452_n2116# pga_final_0/opamp_2stage_final_0/m3_pmos_0/a_52_n2208# 0.29587f
C66 bias_final_0/bias_nmos_1/a_n452_n1808# bias_final_0/bias_nmos_1/a_n52_n1716# 0.23658f
C67 bias_final_0/bias_nmos_0/a_52_n1808# bias_final_0/bias_nmos_0/a_n452_n1808# 0.05997f
C68 sh_final_0/opamp_2stage_final_0/m3_pmos_0/a_n452_24# sh_final_0/opamp_2stage_final_0/m3_pmos_0/a_n52_116# 0.29587f
C69 pga_final_0/opamp_2stage_final_0/m4_pmos_0/w_n1220_n4604# pga_final_0/opamp_2stage_final_0/m4_pmos_0/a_n956_24# 0.50114f
C70 pga_final_0/opamp_2stage_final_0/m6_pmos_0/a_356_n8208# pga_final_0/opamp_2stage_final_0/m6_pmos_0/a_356_n16440# 0.18596f
C71 sh_final_0/opamp_2stage_final_0/m7_nmos_0/a_n452_4256# sh_final_0/opamp_2stage_final_0/m7_nmos_0/a_52_4256# 0.05997f
C72 pga_final_0/opamp_2stage_final_0/m3_pmos_0/w_n1220_n4604# pga_final_0/opamp_2stage_final_0/m3_pmos_0/a_956_116# 1.24508f
C73 sh_final_0/opamp_2stage_final_0/m4_pmos_0/a_452_n2116# sh_final_0/opamp_2stage_final_0/m4_pmos_0/a_n52_n2116# 0.19606f
C74 pga_final_0/opamp_2stage_final_0/m4_pmos_0/a_n556_n2116# pga_final_0/opamp_2stage_final_0/m4_pmos_0/a_n956_n2208# 0.29587f
C75 pga_final_0/opamp_2stage_final_0/m4_pmos_0/a_n556_116# pga_final_0/opamp_2stage_final_0/m4_pmos_0/a_n956_24# 0.29587f
C76 sh_final_0/opamp_2stage_final_0/m5_nmos_0/a_52_24# sh_final_0/opamp_2stage_final_0/m5_nmos_0/a_52_n2208# 0.37451f
C77 pga_final_0/opamp_2stage_final_0/m7_nmos_0/a_556_n4208# pga_final_0/opamp_2stage_final_0/m7_nmos_0/a_556_24# 0.37451f
C78 sh_final_0/sw_nmos_1/a_100_n400# sh_final_0/sw_nmos_1/a_n100_n492# 0.08505f
C79 bias_final_0/bias_nmos_1/a_n52_116# bias_final_0/m2_n100_6000# 0.29384f
C80 sh_final_0/opamp_2stage_final_0/m4_pmos_0/a_452_2348# sh_final_0/opamp_2stage_final_0/m4_pmos_0/a_556_2256# 0.29587f
C81 sh_final_0/opamp_2stage_final_0/m2_nmos_0/a_52_4256# sh_final_0/opamp_2stage_final_0/m2_nmos_0/a_556_4256# 0.05997f
C82 pga_final_0/opamp_2stage_final_0/m4_pmos_0/a_956_n2116# pga_final_0/opamp_2stage_final_0/m4_pmos_0/a_452_n2116# 0.19606f
C83 sh_final_0/opamp_2stage_final_0/m1_nmos_0/a_n956_n8440# sh_final_0/opamp_2stage_final_0/m1_nmos_0/a_n1044_n8348# 0.59234f
C84 sh_final_0/opamp_2stage_final_0/m5_nmos_0/a_956_2348# sh_final_0/opamp_2stage_final_0/m5_nmos_0/a_556_2256# 0.29587f
C85 sh_final_0/opamp_2stage_final_0/m1_nmos_0/a_n556_4348# sh_final_0/opamp_2stage_final_0/m1_nmos_0/a_n956_4256# 0.59234f
C86 sh_final_0/opamp_2stage_final_0/m2_nmos_0/a_n956_n4208# sh_final_0/opamp_2stage_final_0/m2_nmos_0/a_n1044_n4116# 0.59234f
C87 pga_final_0/opamp_2stage_final_0/m2_nmos_0/a_n452_n8440# pga_final_0/opamp_2stage_final_0/m2_nmos_0/a_52_n8440# 0.05997f
C88 pga_final_0/opamp_2stage_final_0/m4_pmos_0/a_452_n4348# pga_final_0/opamp_2stage_final_0/m4_pmos_0/a_556_n4440# 0.29587f
C89 pga_final_0/opamp_2stage_final_0/m2_nmos_0/a_n956_n4208# pga_final_0/opamp_2stage_final_0/m2_nmos_0/a_n956_n8440# 0.37451f
C90 sh_final_0/opamp_2stage_final_0/m3_pmos_0/a_n556_n4348# sh_final_0/opamp_2stage_final_0/m3_pmos_0/a_n1044_n4348# 0.19606f
C91 sh_final_0/opamp_2stage_final_0/m2_nmos_0/a_n52_n4116# sh_final_0/opamp_2stage_final_0/m2_nmos_0/a_n556_n4116# 0.39251f
C92 pga_final_0/opamp_2stage_final_0/m7_nmos_0/a_n52_n4116# pga_final_0/opamp_2stage_final_0/m7_nmos_0/a_452_n4116# 0.39251f
C93 pga_final_0/opamp_2stage_final_0/m7_nmos_0/a_n956_4256# pga_final_0/opamp_2stage_final_0/m7_nmos_0/a_n1044_4348# 0.59234f
C94 sh_final_0/opamp_2stage_final_0/m7_nmos_0/a_556_24# sh_final_0/opamp_2stage_final_0/m7_nmos_0/a_452_116# 0.59234f
C95 pga_final_0/opamp_2stage_final_0/m4_pmos_0/a_n452_2256# pga_final_0/opamp_2stage_final_0/m4_pmos_0/a_52_2256# 0.05997f
C96 sh_final_0/opamp_2stage_final_0/m6_pmos_0/a_556_116# sh_final_0/opamp_2stage_final_0/m6_pmos_0/a_252_116# 1.43738f
C97 sh_final_0/opamp_2stage_final_0/m2_nmos_0/a_n556_116# sh_final_0/opamp_2stage_final_0/m2_nmos_0/a_n956_24# 0.59234f
C98 sh_final_0/opamp_2stage_final_0/m4_pmos_0/a_452_116# sh_final_0/opamp_2stage_final_0/m4_pmos_0/a_n52_116# 0.19606f
C99 sh_final_0/opamp_2stage_final_0/m3_pmos_0/a_452_2348# sh_final_0/opamp_2stage_final_0/m3_pmos_0/a_956_2348# 0.19606f
C100 sh_final_0/opamp_2stage_final_0/m3_pmos_0/a_n556_2348# sh_final_0/opamp_2stage_final_0/m3_pmos_0/a_n452_2256# 0.29587f
C101 sh_final_0/opamp_2stage_final_0/m1_nmos_0/a_n556_n4116# sh_final_0/opamp_2stage_final_0/m1_nmos_0/a_n452_n4208# 0.59234f
C102 pga_final_0/opamp_2stage_final_0/m2_nmos_0/a_n956_4256# pga_final_0/opamp_2stage_final_0/m2_nmos_0/a_n452_4256# 0.05997f
C103 sh_final_0/opamp_2stage_final_0/m3_pmos_0/a_n52_n2116# sh_final_0/opamp_2stage_final_0/m3_pmos_0/a_52_n2208# 0.29587f
C104 pga_final_0/opamp_2stage_final_0/m7_nmos_0/a_n452_n4208# pga_final_0/opamp_2stage_final_0/m7_nmos_0/a_n452_n8440# 0.37451f
C105 pga_final_0/opamp_2stage_final_0/m6_pmos_0/a_52_24# pga_final_0/opamp_2stage_final_0/m6_pmos_0/a_n252_24# 0.05997f
C106 sh_final_0/opamp_2stage_final_0/m4_pmos_0/a_n1044_n4348# sh_final_0/opamp_2stage_final_0/m4_pmos_0/a_n556_n4348# 0.19606f
C107 sh_final_0/opamp_2stage_final_0/m1_n2152_32500# sh_final_0/opamp_2stage_final_0/m6_pmos_0/a_252_116# 1.30923f
C108 pga_final_0/opamp_2stage_final_0/m4_pmos_0/a_556_n2208# pga_final_0/opamp_2stage_final_0/m4_pmos_0/a_556_n4440# 0.37451f
C109 sh_final_0/opamp_2stage_final_0/m3_pmos_0/a_n956_n4440# sh_final_0/opamp_2stage_final_0/m3_pmos_0/a_n956_n2208# 0.37451f
C110 pga_final_0/opamp_2stage_final_0/m4_pmos_0/a_52_2256# pga_final_0/opamp_2stage_final_0/m4_pmos_0/a_452_2348# 0.29587f
C111 sh_final_0/opamp_2stage_final_0/m4_pmos_0/a_556_24# sh_final_0/opamp_2stage_final_0/m4_pmos_0/w_n1220_n4604# 0.50114f
C112 pga_final_0/opamp_2stage_final_0/m4_pmos_0/a_52_n2208# pga_final_0/opamp_2stage_final_0/m4_pmos_0/a_452_n2116# 0.29587f
C113 pga_final_0/opamp_2stage_final_0/m7_nmos_0/a_556_n4208# pga_final_0/opamp_2stage_final_0/m7_nmos_0/a_452_n4116# 0.59234f
C114 pga_final_0/opamp_2stage_final_0/m1_nmos_0/a_556_n4208# pga_final_0/opamp_2stage_final_0/m1_nmos_0/a_556_24# 0.37451f
C115 sh_final_0/opamp_2stage_final_0/m2_nmos_0/a_n956_n4208# sh_final_0/opamp_2stage_final_0/m2_nmos_0/a_n956_n8440# 0.37451f
C116 pga_final_0/opamp_2stage_final_0/m1_nmos_0/a_n52_n4116# pga_final_0/opamp_2stage_final_0/m1_nmos_0/a_52_n4208# 0.59234f
C117 pga_final_0/opamp_2stage_final_0/m4_pmos_0/w_n1220_n4604# pga_final_0/opamp_2stage_final_0/m4_pmos_0/a_956_n2116# 1.24508f
C118 sh_final_0/opamp_2stage_final_0/m1_nmos_0/a_n1044_116# sh_final_0/opamp_2stage_final_0/m1_nmos_0/a_n956_24# 0.59234f
C119 pga_final_0/opamp_2stage_final_0/m5_nmos_0/a_n52_n4348# pga_final_0/opamp_2stage_final_0/m5_nmos_0/a_n452_n4440# 0.29587f
C120 bias_final_0/bias_nmos_0/a_n540_n1716# bias_final_0/bias_nmos_0/a_n452_n1808# 0.23658f
C121 sh_final_0/opamp_2stage_final_0/m6_pmos_0/a_556_n8116# sh_final_0/opamp_2stage_final_0/m6_pmos_0/a_252_n8116# 1.43738f
C122 sh_final_0/opamp_2stage_final_0/m1_n2152_32500# sh_final_0/opamp_2stage_final_0/m6_pmos_0/a_n356_116# 1.30923f
C123 pga_final_0/opamp_2stage_final_0/m1_nmos_0/a_556_n4208# pga_final_0/opamp_2stage_final_0/m1_nmos_0/a_556_n8440# 0.37451f
C124 pga_final_0/opamp_2stage_final_0/m3_pmos_0/a_452_n4348# pga_final_0/opamp_2stage_final_0/m3_pmos_0/a_52_n4440# 0.29587f
C125 sh_final_0/opamp_2stage_final_0/m3_pmos_0/a_52_2256# sh_final_0/opamp_2stage_final_0/m3_pmos_0/a_n452_2256# 0.05997f
C126 pga_final_0/opamp_2stage_final_0/m4_pmos_0/a_n556_n4348# pga_final_0/opamp_2stage_final_0/m4_pmos_0/w_n1220_n4604# 0.47456f
C127 sh_final_0/opamp_2stage_final_0/m7_nmos_0/a_n52_4348# sh_final_0/opamp_2stage_final_0/m7_nmos_0/a_52_4256# 0.59234f
C128 sh_final_0/opamp_2stage_final_0/m4_pmos_0/a_52_n4440# sh_final_0/opamp_2stage_final_0/m4_pmos_0/w_n1220_n4604# 0.71938f
C129 pga_final_0/opamp_2stage_final_0/m5_nmos_0/a_n452_2256# pga_final_0/opamp_2stage_final_0/m5_nmos_0/a_n956_2256# 0.05997f
C130 pga_final_0/opamp_2stage_final_0/m3_pmos_0/a_n52_116# pga_final_0/opamp_2stage_final_0/m3_pmos_0/a_452_116# 0.19606f
C131 sh_final_0/opamp_2stage_final_0/m2_nmos_0/a_n1044_4348# sh_final_0/opamp_2stage_final_0/m2_nmos_0/a_n556_4348# 0.39251f
C132 pga_final_0/opamp_2stage_final_0/m1_nmos_0/a_n452_n4208# pga_final_0/opamp_2stage_final_0/m1_nmos_0/a_n452_24# 0.37451f
C133 sh_final_0/opamp_2stage_final_0/m5_nmos_0/a_452_n4348# sh_final_0/opamp_2stage_final_0/m5_nmos_0/a_556_n4440# 0.29587f
C134 sh_final_0/opamp_2stage_final_0/m5_nmos_0/a_n52_n4348# sh_final_0/opamp_2stage_final_0/m5_nmos_0/a_n556_n4348# 0.19606f
C135 pga_final_0/opamp_2stage_final_0/m3_pmos_0/w_n1220_n4604# pga_final_0/opamp_2stage_final_0/m3_pmos_0/a_n956_n4440# 0.76217f
C136 sh_final_0/opamp_2stage_final_0/m2_nmos_0/a_n52_n4116# sh_final_0/opamp_2stage_final_0/m2_nmos_0/a_n452_n4208# 0.59234f
C137 sh_final_0/opamp_2stage_final_0/m7_nmos_0/a_52_n8440# sh_final_0/opamp_2stage_final_0/m7_nmos_0/a_n452_n8440# 0.05997f
C138 sh_final_0/opamp_2stage_final_0/m3_pmos_0/w_n1220_n4604# sh_final_0/opamp_2stage_final_0/m3_pmos_0/a_556_n2208# 0.50114f
C139 bias_final_0/bias_nmos_0/a_n52_116# bias_final_0/bias_nmos_0/a_52_24# 0.23658f
C140 pga_final_0/opamp_2stage_final_0/m4_pmos_0/a_n1044_2348# pga_final_0/opamp_2stage_final_0/m4_pmos_0/w_n1220_n4604# 1.26104f
C141 pga_final_0/opamp_2stage_final_0/m1_nmos_0/a_556_n4208# pga_final_0/opamp_2stage_final_0/m1_nmos_0/a_52_n4208# 0.05997f
C142 sh_final_0/opamp_2stage_final_0/m1_nmos_0/a_n956_4256# sh_final_0/opamp_2stage_final_0/m1_nmos_0/a_n1044_4348# 0.59234f
C143 sh_final_0/opamp_2stage_final_0/m3_pmos_0/w_n1220_n4604# sh_final_0/opamp_2stage_final_0/m3_pmos_0/a_956_n2116# 1.24508f
C144 sh_final_0/opamp_2stage_final_0/m6_pmos_0/a_52_n8208# sh_final_0/opamp_2stage_final_0/m6_pmos_0/a_52_n16440# 0.18596f
C145 sh_final_0/opamp_2stage_final_0/m1_nmos_0/a_n452_4256# sh_final_0/opamp_2stage_final_0/m1_nmos_0/a_n452_24# 0.37451f
C146 sh_final_0/opamp_2stage_final_0/m3_pmos_0/a_n452_24# sh_final_0/opamp_2stage_final_0/m3_pmos_0/a_n556_116# 0.29587f
C147 sh_final_0/opamp_2stage_final_0/m3_pmos_0/a_n956_24# sh_final_0/opamp_2stage_final_0/m3_pmos_0/a_n956_2256# 0.37451f
C148 pga_final_0/opamp_2stage_final_0/m1_nmos_0/a_n556_n4116# pga_final_0/opamp_2stage_final_0/m1_nmos_0/a_n1044_n4116# 0.39251f
C149 pga_final_0/opamp_2stage_final_0/m4_pmos_0/a_52_n2208# pga_final_0/opamp_2stage_final_0/m4_pmos_0/a_n452_n2208# 0.05997f
C150 sh_final_0/opamp_2stage_final_0/m3_pmos_0/a_52_n2208# sh_final_0/opamp_2stage_final_0/m3_pmos_0/a_52_24# 0.37451f
C151 sh_final_0/opamp_2stage_final_0/m5_nmos_0/a_n52_n2116# sh_final_0/opamp_2stage_final_0/m5_nmos_0/a_452_n2116# 0.19606f
C152 pga_final_0/opamp_2stage_final_0/m6_pmos_0/a_356_24# pga_final_0/opamp_2stage_final_0/m6_pmos_0/a_356_8256# 0.18596f
C153 sh_final_0/opamp_2stage_final_0/m4_pmos_0/a_n1044_116# sh_final_0/opamp_2stage_final_0/m4_pmos_0/a_n956_24# 0.29587f
C154 pga_final_0/opamp_2stage_final_0/m4_pmos_0/a_556_24# pga_final_0/opamp_2stage_final_0/m4_pmos_0/a_556_n2208# 0.37451f
C155 pga_final_0/opamp_2stage_final_0/m2_nmos_0/a_556_4256# pga_final_0/opamp_2stage_final_0/m2_nmos_0/a_956_4348# 0.59234f
C156 sh_final_0/opamp_2stage_final_0/m4_pmos_0/a_956_n4348# sh_final_0/opamp_2stage_final_0/m4_pmos_0/a_452_n4348# 0.19606f
C157 pga_final_0/opamp_2stage_final_0/m7_nmos_0/a_n1044_n4116# pga_final_0/opamp_2stage_final_0/m7_nmos_0/a_n956_n4208# 0.59234f
C158 pga_final_0/opamp_2stage_final_0/m4_pmos_0/a_52_n2208# pga_final_0/opamp_2stage_final_0/m4_pmos_0/w_n1220_n4604# 0.45835f
C159 pga_final_0/opamp_2stage_final_0/m7_nmos_0/a_n556_116# pga_final_0/opamp_2stage_final_0/m7_nmos_0/a_n452_24# 0.59234f
C160 pga_final_0/opamp_2stage_final_0/m1_nmos_0/a_52_n8440# pga_final_0/opamp_2stage_final_0/m1_nmos_0/a_556_n8440# 0.05997f
C161 sh_final_0/opamp_2stage_final_0/m6_pmos_0/a_n252_24# sh_final_0/opamp_2stage_final_0/m6_pmos_0/a_n356_116# 0.85436f
C162 pga_final_0/opamp_2stage_final_0/m1_nmos_0/a_n52_116# pga_final_0/opamp_2stage_final_0/m1_nmos_0/a_452_116# 0.39251f
C163 pga_final_0/opamp_2stage_final_0/m3_pmos_0/a_n1044_n2116# pga_final_0/opamp_2stage_final_0/m3_pmos_0/a_n556_n2116# 0.19606f
C164 sh_final_0/opamp_2stage_final_0/m1_nmos_0/a_n956_4256# sh_final_0/opamp_2stage_final_0/m1_nmos_0/a_n452_4256# 0.05997f
C165 pga_final_0/r_fb_0/a_n200_8000# pga_final_0/m2_18000_25850# 0.10996f
C166 pga_final_0/opamp_2stage_final_0/m7_nmos_0/a_n556_n4116# pga_final_0/opamp_2stage_final_0/m7_nmos_0/a_n956_n4208# 0.59234f
C167 sh_final_0/opamp_2stage_final_0/m4_pmos_0/a_556_2256# sh_final_0/opamp_2stage_final_0/m4_pmos_0/w_n1220_n4604# 0.76217f
C168 pga_final_0/opamp_2stage_final_0/m2_nmos_0/a_n556_116# pga_final_0/opamp_2stage_final_0/m2_nmos_0/a_n1044_116# 0.39251f
C169 pga_final_0/opamp_2stage_final_0/m3_pmos_0/a_n556_n2116# pga_final_0/opamp_2stage_final_0/m3_pmos_0/a_n956_n2208# 0.29587f
C170 sh_final_0/opamp_2stage_final_0/m7_nmos_0/a_n956_n4208# sh_final_0/opamp_2stage_final_0/m7_nmos_0/a_n1044_n4116# 0.59234f
C171 sh_final_0/opamp_2stage_final_0/m7_nmos_0/a_n452_n4208# sh_final_0/opamp_2stage_final_0/m7_nmos_0/a_52_n4208# 0.05997f
C172 pga_final_0/opamp_2stage_final_0/m1_nmos_0/a_n556_n4116# pga_final_0/opamp_2stage_final_0/m1_nmos_0/a_n452_n4208# 0.59234f
C173 sh_final_0/opamp_2stage_final_0/m4_pmos_0/w_n1220_n4604# sh_final_0/opamp_2stage_final_0/m4_pmos_0/a_452_n4348# 0.47456f
C174 sh_final_0/opamp_2stage_final_0/m3_pmos_0/w_n1220_n4604# sh_final_0/opamp_2stage_final_0/m3_pmos_0/a_n52_2348# 0.47455f
C175 sh_final_0/opamp_2stage_final_0/m5_nmos_0/a_n452_n2208# sh_final_0/opamp_2stage_final_0/m5_nmos_0/a_n452_24# 0.37451f
C176 pga_final_0/opamp_2stage_final_0/m1_nmos_0/a_52_n8440# pga_final_0/opamp_2stage_final_0/m1_nmos_0/a_52_n4208# 0.37451f
C177 sh_final_0/opamp_2stage_final_0/m3_pmos_0/a_556_n4440# sh_final_0/opamp_2stage_final_0/m3_pmos_0/a_956_n4348# 0.29587f
C178 sh_final_0/opamp_2stage_final_0/m4_pmos_0/a_452_n2116# sh_final_0/opamp_2stage_final_0/m4_pmos_0/w_n1220_n4604# 0.45674f
C179 sh_final_0/opamp_2stage_final_0/m5_nmos_0/a_n52_2348# sh_final_0/opamp_2stage_final_0/m5_nmos_0/a_52_2256# 0.29587f
C180 sh_final_0/opamp_2stage_final_0/m3_pmos_0/w_n1220_n4604# sh_final_0/opamp_2stage_final_0/m3_pmos_0/a_n556_n4348# 0.47456f
C181 pga_final_0/opamp_2stage_final_0/m4_pmos_0/a_452_n4348# pga_final_0/opamp_2stage_final_0/m4_pmos_0/a_52_n4440# 0.29587f
C182 sh_final_0/opamp_2stage_final_0/m7_nmos_0/a_52_24# sh_final_0/opamp_2stage_final_0/m7_nmos_0/a_52_4256# 0.37451f
C183 sh_final_0/opamp_2stage_final_0/m2_nmos_0/a_52_n4208# sh_final_0/opamp_2stage_final_0/m2_nmos_0/a_52_24# 0.37451f
C184 pga_final_0/opamp_2stage_final_0/m3_pmos_0/a_n556_n2116# pga_final_0/opamp_2stage_final_0/m3_pmos_0/a_n52_n2116# 0.19606f
C185 bias_final_0/bias_nmos_1/a_n452_24# bias_final_0/m2_n100_6000# 0.20206f
C186 pga_final_0/opamp_2stage_final_0/m5_nmos_0/a_n556_n2116# pga_final_0/opamp_2stage_final_0/m5_nmos_0/a_n1044_n2116# 0.19606f
C187 sh_final_0/opamp_2stage_final_0/m4_pmos_0/a_556_24# sh_final_0/opamp_2stage_final_0/m4_pmos_0/a_52_24# 0.05997f
C188 sh_final_0/opamp_2stage_final_0/m5_nmos_0/a_n452_n2208# sh_final_0/opamp_2stage_final_0/m5_nmos_0/a_52_n2208# 0.05997f
C189 sh_final_0/opamp_2stage_final_0/m2_nmos_0/a_n556_n4116# sh_final_0/opamp_2stage_final_0/m2_nmos_0/a_n1044_n4116# 0.39251f
C190 pga_final_0/opamp_2stage_final_0/m1_nmos_0/a_556_24# pga_final_0/opamp_2stage_final_0/m1_nmos_0/a_452_116# 0.59234f
C191 pga_final_0/opamp_2stage_final_0/m5_nmos_0/a_n452_24# pga_final_0/opamp_2stage_final_0/m5_nmos_0/a_n452_n2208# 0.37451f
C192 pga_final_0/opamp_2stage_final_0/m2_nmos_0/a_n52_4348# pga_final_0/opamp_2stage_final_0/m2_nmos_0/a_52_4256# 0.59234f
C193 sh_final_0/opamp_2stage_final_0/m1_nmos_0/a_452_n4116# sh_final_0/opamp_2stage_final_0/m1_nmos_0/a_52_n4208# 0.59234f
C194 sh_final_0/opamp_2stage_final_0/m2_nmos_0/a_556_n8440# sh_final_0/opamp_2stage_final_0/m2_nmos_0/a_956_n8348# 0.59234f
C195 pga_final_0/opamp_2stage_final_0/m3_pmos_0/a_52_2256# pga_final_0/opamp_2stage_final_0/m3_pmos_0/a_n452_2256# 0.05997f
C196 pga_final_0/opamp_2stage_final_0/m3_pmos_0/a_n956_2256# pga_final_0/opamp_2stage_final_0/m3_pmos_0/a_n1044_2348# 0.29587f
C197 bias_final_0/bias_nmos_1/a_52_n1808# bias_final_0/bias_nmos_1/a_n452_n1808# 0.05997f
C198 pga_final_0/opamp_2stage_final_0/m1_nmos_0/a_n556_116# pga_final_0/opamp_2stage_final_0/m1_nmos_0/a_n1044_116# 0.39251f
C199 sh_final_0/opamp_2stage_final_0/m4_pmos_0/a_452_2348# sh_final_0/opamp_2stage_final_0/m4_pmos_0/a_n52_2348# 0.19606f
C200 sh_final_0/opamp_2stage_final_0/m4_pmos_0/a_n1044_n2116# sh_final_0/opamp_2stage_final_0/m4_pmos_0/w_n1220_n4604# 1.24508f
C201 sh_final_0/opamp_2stage_final_0/m3_pmos_0/a_52_n2208# sh_final_0/opamp_2stage_final_0/m3_pmos_0/w_n1220_n4604# 0.45835f
C202 pga_final_0/opamp_2stage_final_0/m4_pmos_0/a_n452_n4440# pga_final_0/opamp_2stage_final_0/m4_pmos_0/a_n956_n4440# 0.05997f
C203 sh_final_0/opamp_2stage_final_0/m1_nmos_0/a_52_n8440# sh_final_0/opamp_2stage_final_0/m1_nmos_0/a_52_n4208# 0.37451f
C204 sh_final_0/opamp_2stage_final_0/m5_nmos_0/a_n452_24# sh_final_0/opamp_2stage_final_0/m5_nmos_0/a_n452_2256# 0.37451f
C205 pga_final_0/opamp_2stage_final_0/m7_nmos_0/a_52_n8440# pga_final_0/opamp_2stage_final_0/m7_nmos_0/a_n52_n8348# 0.59234f
C206 sh_final_0/opamp_2stage_final_0/m1_nmos_0/a_n556_4348# sh_final_0/opamp_2stage_final_0/m1_nmos_0/a_n52_4348# 0.39251f
C207 sh_final_0/opamp_2stage_final_0/m7_nmos_0/a_52_n8440# sh_final_0/opamp_2stage_final_0/m7_nmos_0/a_n52_n8348# 0.59234f
C208 pga_final_0/opamp_2stage_final_0/m3_pmos_0/w_n1220_n4604# pga_final_0/opamp_2stage_final_0/m3_pmos_0/a_n452_n4440# 0.71938f
C209 sh_final_0/opamp_2stage_final_0/m2_nmos_0/a_956_n4116# sh_final_0/opamp_2stage_final_0/m2_nmos_0/a_452_n4116# 0.39251f
C210 pga_final_0/opamp_2stage_final_0/m7_nmos_0/a_n52_n4116# pga_final_0/opamp_2stage_final_0/m7_nmos_0/a_n556_n4116# 0.39251f
C211 sh_final_0/opamp_2stage_final_0/m7_nmos_0/a_n52_116# sh_final_0/opamp_2stage_final_0/m7_nmos_0/a_452_116# 0.39251f
C212 pga_final_0/opamp_2stage_final_0/m5_nmos_0/a_n452_24# pga_final_0/opamp_2stage_final_0/m5_nmos_0/a_n452_2256# 0.37451f
C213 pga_final_0/opamp_2stage_final_0/m5_nmos_0/a_956_2348# pga_final_0/opamp_2stage_final_0/m5_nmos_0/a_556_2256# 0.29587f
C214 sh_final_0/opamp_2stage_final_0/m6_pmos_0/a_52_n8208# sh_final_0/opamp_2stage_final_0/m6_pmos_0/a_52_24# 0.18596f
C215 pga_final_0/opamp_2stage_final_0/m4_pmos_0/a_52_n2208# pga_final_0/opamp_2stage_final_0/m4_pmos_0/a_n52_n2116# 0.29587f
C216 pga_final_0/opamp_2stage_final_0/m6_pmos_0/a_n252_n16440# pga_final_0/opamp_2stage_final_0/m6_pmos_0/a_n252_n8208# 0.18596f
C217 pga_final_0/opamp_2stage_final_0/m6_pmos_0/a_n52_n8116# pga_final_0/opamp_2stage_final_0/m6_pmos_0/a_52_n8208# 0.85436f
C218 sh_final_0/opamp_2stage_final_0/m3_pmos_0/a_452_n4348# sh_final_0/opamp_2stage_final_0/m3_pmos_0/a_n52_n4348# 0.19606f
C219 pga_final_0/opamp_2stage_final_0/m3_pmos_0/a_452_2348# pga_final_0/opamp_2stage_final_0/m3_pmos_0/a_956_2348# 0.19606f
C220 pga_final_0/opamp_2stage_final_0/m3_pmos_0/w_n1220_n4604# pga_final_0/opamp_2stage_final_0/m3_pmos_0/a_n52_2348# 0.47455f
C221 sh_final_0/opamp_2stage_final_0/m2_nmos_0/a_n452_24# sh_final_0/opamp_2stage_final_0/m2_nmos_0/a_n956_24# 0.05997f
C222 pga_final_0/opamp_2stage_final_0/m7_nmos_0/a_n956_24# pga_final_0/opamp_2stage_final_0/m7_nmos_0/a_n1044_116# 0.59234f
C223 pga_final_0/opamp_2stage_final_0/m3_pmos_0/a_556_24# pga_final_0/opamp_2stage_final_0/m3_pmos_0/a_556_2256# 0.37451f
C224 pga_final_0/opamp_2stage_final_0/m2_nmos_0/a_n452_n8440# pga_final_0/opamp_2stage_final_0/m2_nmos_0/a_n956_n8440# 0.05997f
C225 sh_final_0/opamp_2stage_final_0/m3_pmos_0/w_n1220_n4604# sh_final_0/opamp_2stage_final_0/m3_pmos_0/a_n1044_116# 1.24508f
C226 bias_final_0/bias_nmos_0/a_n452_24# bias_final_0/bias_nmos_0/a_n540_116# 0.23658f
C227 pga_final_0/opamp_2stage_final_0/m2_nmos_0/a_452_116# pga_final_0/opamp_2stage_final_0/m2_nmos_0/a_556_24# 0.59234f
C228 pga_final_0/opamp_2stage_final_0/m4_pmos_0/w_n1220_n4604# pga_final_0/opamp_2stage_final_0/m4_pmos_0/a_956_2348# 1.26104f
C229 pga_final_0/opamp_2stage_final_0/m3_pmos_0/a_52_n2208# pga_final_0/opamp_2stage_final_0/m3_pmos_0/a_n52_n2116# 0.29587f
C230 pga_final_0/opamp_2stage_final_0/m6_pmos_0/a_n356_116# pga_final_0/opamp_2stage_final_0/m6_pmos_0/a_n252_24# 0.85436f
C231 pga_final_0/opamp_2stage_final_0/m2_nmos_0/a_n52_n4116# pga_final_0/opamp_2stage_final_0/m2_nmos_0/a_n556_n4116# 0.39251f
C232 sh_final_0/opamp_2stage_final_0/m4_pmos_0/a_n52_116# sh_final_0/opamp_2stage_final_0/m4_pmos_0/w_n1220_n4604# 0.45673f
C233 sh_final_0/opamp_2stage_final_0/m1_n2152_32500# sh_final_0/opamp_2stage_final_0/m2_7152_15850# 0.1955f
C234 sh_final_0/opamp_2stage_final_0/m2_nmos_0/a_556_n4208# sh_final_0/opamp_2stage_final_0/m2_nmos_0/a_556_n8440# 0.37451f
C235 pga_final_0/opamp_2stage_final_0/m2_nmos_0/a_n1044_n4116# pga_final_0/opamp_2stage_final_0/m2_nmos_0/a_n556_n4116# 0.39251f
C236 sh_final_0/opamp_2stage_final_0/m2_nmos_0/a_n556_4348# sh_final_0/opamp_2stage_final_0/m2_nmos_0/a_n956_4256# 0.59234f
C237 pga_final_0/opamp_2stage_final_0/m4_pmos_0/w_n1220_n4604# pga_final_0/opamp_2stage_final_0/m4_pmos_0/a_556_n4440# 0.76217f
C238 pga_final_0/opamp_2stage_final_0/m5_nmos_0/a_n52_n4348# pga_final_0/opamp_2stage_final_0/m5_nmos_0/a_n556_n4348# 0.19606f
C239 pga_final_0/opamp_2stage_final_0/m1_nmos_0/a_n956_n8440# pga_final_0/opamp_2stage_final_0/m1_nmos_0/a_n1044_n8348# 0.59234f
C240 pga_final_0/opamp_2stage_final_0/m1_nmos_0/a_n52_4348# pga_final_0/opamp_2stage_final_0/m1_nmos_0/a_n452_4256# 0.59234f
C241 pga_final_0/opamp_2stage_final_0/m4_pmos_0/a_n556_n4348# pga_final_0/opamp_2stage_final_0/m4_pmos_0/a_n52_n4348# 0.19606f
C242 pga_final_0/opamp_2stage_final_0/m4_pmos_0/a_n956_24# pga_final_0/opamp_2stage_final_0/m4_pmos_0/a_n956_2256# 0.37451f
C243 pga_final_0/opamp_2stage_final_0/m5_nmos_0/a_n556_2348# pga_final_0/opamp_2stage_final_0/m5_nmos_0/a_n452_2256# 0.29587f
C244 sh_final_0/opamp_2stage_final_0/m4_pmos_0/a_n1044_n2116# sh_final_0/opamp_2stage_final_0/m4_pmos_0/a_n956_n2208# 0.29587f
C245 sh_final_0/opamp_2stage_final_0/m2_nmos_0/a_556_n4208# sh_final_0/opamp_2stage_final_0/m2_nmos_0/a_52_n4208# 0.05997f
C246 pga_final_0/opamp_2stage_final_0/m5_nmos_0/a_52_n2208# pga_final_0/opamp_2stage_final_0/m5_nmos_0/a_556_n2208# 0.05997f
C247 sh_final_0/opamp_2stage_final_0/m6_pmos_0/a_356_n8208# sh_final_0/opamp_2stage_final_0/m1_n2152_32500# 0.29128f
C248 pga_final_0/opamp_2stage_final_0/m4_pmos_0/w_n1220_n4604# pga_final_0/opamp_2stage_final_0/m4_pmos_0/a_556_2256# 0.76217f
C249 pga_final_0/opamp_2stage_final_0/m6_pmos_0/a_556_n8116# pga_final_0/opamp_2stage_final_0/m6_pmos_0/a_252_n8116# 1.43738f
C250 sh_final_0/sw_nmos_0/a_n188_n400# sh_final_0/sw_nmos_0/a_100_n400# 0.14309f
C251 sh_final_0/opamp_2stage_final_0/m1_nmos_0/a_n52_n4116# sh_final_0/opamp_2stage_final_0/m1_nmos_0/a_52_n4208# 0.59234f
C252 bias_final_0/bias_nmos_0/a_52_n1808# bias_final_0/bias_nmos_0/a_n52_n1716# 0.23658f
C253 pga_final_0/opamp_2stage_final_0/m1_nmos_0/a_n956_4256# pga_final_0/opamp_2stage_final_0/m1_nmos_0/a_n556_4348# 0.59234f
C254 sh_final_0/opamp_2stage_final_0/m3_pmos_0/w_n1220_n4604# sh_final_0/opamp_2stage_final_0/m3_pmos_0/a_n52_n4348# 0.47455f
C255 sh_final_0/opamp_2stage_final_0/m3_pmos_0/a_452_2348# sh_final_0/opamp_2stage_final_0/m3_pmos_0/a_52_2256# 0.29587f
C256 pga_final_0/opamp_2stage_final_0/m3_pmos_0/w_n1220_n4604# pga_final_0/opamp_2stage_final_0/m3_pmos_0/a_n1044_2348# 1.26104f
C257 pga_final_0/opamp_2stage_final_0/m5_nmos_0/a_n956_24# pga_final_0/opamp_2stage_final_0/m5_nmos_0/a_n556_116# 0.29587f
C258 pga_final_0/opamp_2stage_final_0/m5_nmos_0/a_n452_24# pga_final_0/opamp_2stage_final_0/m5_nmos_0/a_n52_116# 0.29587f
C259 pga_final_0/opamp_2stage_final_0/m5_nmos_0/a_n452_n2208# pga_final_0/opamp_2stage_final_0/m5_nmos_0/a_n556_n2116# 0.29587f
C260 sh_final_0/opamp_2stage_final_0/m2_nmos_0/a_n556_116# sh_final_0/opamp_2stage_final_0/m2_nmos_0/a_n52_116# 0.39251f
C261 pga_final_0/opamp_2stage_final_0/m4_pmos_0/a_452_n4348# pga_final_0/opamp_2stage_final_0/m4_pmos_0/a_956_n4348# 0.19606f
C262 pga_final_0/opamp_2stage_final_0/m3_pmos_0/a_52_2256# pga_final_0/opamp_2stage_final_0/m3_pmos_0/a_556_2256# 0.05997f
C263 sh_final_0/opamp_2stage_final_0/m4_pmos_0/a_n556_n2116# sh_final_0/opamp_2stage_final_0/m4_pmos_0/a_n1044_n2116# 0.19606f
C264 pga_final_0/opamp_2stage_final_0/m1_nmos_0/a_452_4348# pga_final_0/opamp_2stage_final_0/m1_nmos_0/a_n52_4348# 0.39251f
C265 sh_final_0/opamp_2stage_final_0/m4_pmos_0/a_n52_116# sh_final_0/opamp_2stage_final_0/m4_pmos_0/a_n452_24# 0.29587f
C266 pga_final_0/opamp_2stage_final_0/m2_nmos_0/a_n52_n8348# pga_final_0/opamp_2stage_final_0/m2_nmos_0/a_n556_n8348# 0.39251f
C267 sh_final_0/opamp_2stage_final_0/m1_n2152_32500# sh_final_0/opamp_2stage_final_0/m6_pmos_0/a_556_116# 4.72381f
C268 sh_final_0/sw_nmos_0/a_100_n400# sh_final_0/sw_nmos_0/a_n100_n492# 0.08505f
C269 sh_final_0/opamp_2stage_final_0/m1_nmos_0/a_956_116# sh_final_0/opamp_2stage_final_0/m1_nmos_0/a_556_24# 0.59234f
C270 bias_final_0/bias_nmos_1/a_52_n1808# bias_final_0/bias_nmos_1/a_n52_n1716# 0.23658f
C271 sh_final_0/opamp_2stage_final_0/m1_n2152_32500# sh_final_0/c_samp_0/m4_n3240_n3120# 0.11779f
C272 sh_final_0/opamp_2stage_final_0/m6_pmos_0/a_356_24# sh_final_0/opamp_2stage_final_0/m6_pmos_0/a_52_24# 0.05997f
C273 pga_final_0/opamp_2stage_final_0/m3_pmos_0/a_n956_2256# pga_final_0/opamp_2stage_final_0/m3_pmos_0/a_n556_2348# 0.29587f
C274 vref_final_0/vref_nmos_0/a_n400_n292# vref_final_0/vref_nmos_0/a_n488_n200# 0.07019f
C275 pga_final_0/opamp_2stage_final_0/m7_nmos_0/a_52_24# pga_final_0/opamp_2stage_final_0/m7_nmos_0/a_52_n4208# 0.37451f
C276 pga_final_0/opamp_2stage_final_0/m7_nmos_0/a_n52_116# pga_final_0/opamp_2stage_final_0/m7_nmos_0/a_52_24# 0.59234f
C277 pga_final_0/opamp_2stage_final_0/m1_nmos_0/a_52_n8440# pga_final_0/opamp_2stage_final_0/m1_nmos_0/a_n452_n8440# 0.05997f
C278 pga_final_0/opamp_2stage_final_0/m7_nmos_0/a_n452_n8440# pga_final_0/opamp_2stage_final_0/m7_nmos_0/a_n52_n8348# 0.59234f
C279 pga_final_0/opamp_2stage_final_0/m7_nmos_0/a_956_n8348# pga_final_0/opamp_2stage_final_0/m7_nmos_0/a_452_n8348# 0.39251f
C280 sh_final_0/opamp_2stage_final_0/m1_nmos_0/a_n52_4348# sh_final_0/opamp_2stage_final_0/m1_nmos_0/a_n452_4256# 0.59234f
C281 sh_final_0/opamp_2stage_final_0/m5_nmos_0/a_n956_n4440# sh_final_0/opamp_2stage_final_0/m5_nmos_0/a_n556_n4348# 0.29587f
C282 sh_final_0/opamp_2stage_final_0/m4_pmos_0/a_n556_2348# sh_final_0/opamp_2stage_final_0/m4_pmos_0/a_n956_2256# 0.29587f
C283 sh_final_0/opamp_2stage_final_0/m4_pmos_0/a_556_2256# sh_final_0/opamp_2stage_final_0/m4_pmos_0/a_52_2256# 0.05997f
C284 sh_final_0/opamp_2stage_final_0/m4_pmos_0/a_n52_2348# sh_final_0/opamp_2stage_final_0/m4_pmos_0/w_n1220_n4604# 0.47455f
C285 pga_final_0/opamp_2stage_final_0/m4_pmos_0/a_556_24# pga_final_0/opamp_2stage_final_0/m4_pmos_0/w_n1220_n4604# 0.50114f
C286 pga_final_0/opamp_2stage_final_0/m1_nmos_0/a_n52_n4116# pga_final_0/opamp_2stage_final_0/m1_nmos_0/a_n452_n4208# 0.59234f
C287 pga_final_0/opamp_2stage_final_0/m3_pmos_0/a_452_n2116# pga_final_0/opamp_2stage_final_0/m3_pmos_0/a_n52_n2116# 0.19606f
C288 sh_final_0/opamp_2stage_final_0/m4_pmos_0/a_n52_n4348# sh_final_0/opamp_2stage_final_0/m4_pmos_0/a_52_n4440# 0.29587f
C289 pga_final_0/opamp_2stage_final_0/m7_nmos_0/a_452_116# pga_final_0/opamp_2stage_final_0/m7_nmos_0/a_52_24# 0.59234f
C290 pga_final_0/opamp_2stage_final_0/m2_nmos_0/a_452_116# pga_final_0/opamp_2stage_final_0/m2_nmos_0/a_n52_116# 0.39251f
C291 pga_final_0/opamp_2stage_final_0/m3_pmos_0/w_n1220_n4604# pga_final_0/opamp_2stage_final_0/m3_pmos_0/a_n452_n2208# 0.45835f
C292 sh_final_0/opamp_2stage_final_0/m4_pmos_0/a_n556_n4348# sh_final_0/opamp_2stage_final_0/m4_pmos_0/w_n1220_n4604# 0.47456f
C293 sh_final_0/opamp_2stage_final_0/m7_nmos_0/a_52_24# sh_final_0/opamp_2stage_final_0/m7_nmos_0/a_452_116# 0.59234f
C294 sh_final_0/opamp_2stage_final_0/m3_pmos_0/a_452_116# sh_final_0/opamp_2stage_final_0/m3_pmos_0/a_52_24# 0.29587f
C295 sh_final_0/opamp_2stage_final_0/m3_pmos_0/a_n452_24# sh_final_0/opamp_2stage_final_0/m3_pmos_0/a_n452_2256# 0.37451f
C296 bias_final_0/bias_nmos_0/a_n452_24# bias_final_0/bias_nmos_0/a_n452_n1808# 0.37451f
C297 sh_final_0/opamp_2stage_final_0/m3_pmos_0/a_52_n4440# sh_final_0/opamp_2stage_final_0/m3_pmos_0/a_52_n2208# 0.37451f
C298 sh_final_0/opamp_2stage_final_0/m1_n2152_32500# sh_final_0/opamp_2stage_final_0/m6_pmos_0/a_n252_n16440# 2.20123f
C299 pga_final_0/opamp_2stage_final_0/m1_nmos_0/a_n452_n8440# pga_final_0/opamp_2stage_final_0/m1_nmos_0/a_n956_n8440# 0.05997f
C300 pga_final_0/opamp_2stage_final_0/m5_nmos_0/a_n956_n4440# pga_final_0/opamp_2stage_final_0/m5_nmos_0/a_n1044_n4348# 0.29587f
C301 sh_final_0/opamp_2stage_final_0/m1_nmos_0/a_n452_n4208# sh_final_0/opamp_2stage_final_0/m1_nmos_0/a_n956_n4208# 0.05997f
C302 sh_final_0/sw_nmos_1/a_100_n400# sh_final_0/sw_nmos_1/a_n188_n400# 0.14309f
C303 pga_final_0/opamp_2stage_final_0/m7_nmos_0/a_52_4256# pga_final_0/opamp_2stage_final_0/m7_nmos_0/a_n452_4256# 0.05997f
C304 pga_final_0/opamp_2stage_final_0/m4_pmos_0/a_n956_24# pga_final_0/opamp_2stage_final_0/m4_pmos_0/a_n452_24# 0.05997f
C305 pga_final_0/opamp_2stage_final_0/m2_nmos_0/a_n452_n4208# pga_final_0/opamp_2stage_final_0/m2_nmos_0/a_n956_n4208# 0.05997f
C306 sh_final_0/opamp_2stage_final_0/m4_pmos_0/a_n52_116# sh_final_0/opamp_2stage_final_0/m4_pmos_0/a_52_24# 0.29587f
C307 pga_final_0/opamp_2stage_final_0/m1_nmos_0/a_n556_n8348# pga_final_0/opamp_2stage_final_0/m1_nmos_0/a_n52_n8348# 0.39251f
C308 sh_final_0/opamp_2stage_final_0/m5_nmos_0/a_n956_n4440# sh_final_0/opamp_2stage_final_0/m5_nmos_0/a_n956_n2208# 0.37451f
C309 bias_final_0/bias_nmos_0/a_n52_n1716# bias_final_0/bias_nmos_0/a_n540_n1716# 0.15677f
C310 pga_final_0/opamp_2stage_final_0/m1_nmos_0/a_452_4348# pga_final_0/opamp_2stage_final_0/m1_nmos_0/a_556_4256# 0.59234f
C311 sh_final_0/opamp_2stage_final_0/m4_pmos_0/a_n52_n2116# sh_final_0/opamp_2stage_final_0/m4_pmos_0/a_n452_n2208# 0.29587f
C312 pga_final_0/opamp_2stage_final_0/m4_pmos_0/a_n1044_2348# pga_final_0/opamp_2stage_final_0/m4_pmos_0/a_n956_2256# 0.29587f
C313 sh_final_0/opamp_2stage_final_0/m7_nmos_0/a_556_n8440# sh_final_0/opamp_2stage_final_0/m7_nmos_0/a_452_n8348# 0.59234f
C314 pga_final_0/opamp_2stage_final_0/m7_nmos_0/a_956_4348# pga_final_0/opamp_2stage_final_0/m7_nmos_0/a_556_4256# 0.59234f
C315 pga_final_0/opamp_2stage_final_0/m5_nmos_0/a_956_n4348# pga_final_0/opamp_2stage_final_0/m5_nmos_0/a_556_n4440# 0.29587f
C316 sh_final_0/opamp_2stage_final_0/m1_nmos_0/a_n52_116# sh_final_0/opamp_2stage_final_0/m1_nmos_0/a_n452_24# 0.59234f
C317 pga_final_0/opamp_2stage_final_0/m4_pmos_0/a_52_24# pga_final_0/opamp_2stage_final_0/m4_pmos_0/w_n1220_n4604# 0.45835f
C318 pga_final_0/opamp_2stage_final_0/m3_pmos_0/a_n956_n2208# pga_final_0/opamp_2stage_final_0/m3_pmos_0/a_n956_24# 0.37451f
C319 sh_final_0/opamp_2stage_final_0/m1_nmos_0/a_n452_n8440# sh_final_0/opamp_2stage_final_0/m1_nmos_0/a_n956_n8440# 0.05997f
C320 sh_final_0/opamp_2stage_final_0/m4_pmos_0/a_52_n4440# sh_final_0/opamp_2stage_final_0/m4_pmos_0/a_n452_n4440# 0.05997f
C321 pga_final_0/opamp_2stage_final_0/m3_pmos_0/w_n1220_n4604# pga_final_0/opamp_2stage_final_0/m3_pmos_0/a_556_n2208# 0.50114f
C322 sh_final_0/opamp_2stage_final_0/m6_pmos_0/a_52_n8208# sh_final_0/opamp_2stage_final_0/m6_pmos_0/a_n252_n8208# 0.05997f
C323 pga_final_0/opamp_2stage_final_0/m5_nmos_0/a_52_n4440# pga_final_0/opamp_2stage_final_0/m5_nmos_0/a_52_n2208# 0.37451f
C324 sh_final_0/opamp_2stage_final_0/m7_nmos_0/a_52_4256# sh_final_0/opamp_2stage_final_0/m7_nmos_0/a_556_4256# 0.05997f
C325 sh_final_0/opamp_2stage_final_0/m3_pmos_0/a_n52_n2116# sh_final_0/opamp_2stage_final_0/m3_pmos_0/w_n1220_n4604# 0.45673f
C326 sh_final_0/opamp_2stage_final_0/m1_n2152_32500# sh_final_0/opamp_2stage_final_0/m6_pmos_0/a_n252_24# 0.25077f
C327 pga_final_0/opamp_2stage_final_0/m2_nmos_0/a_n1044_4348# pga_final_0/opamp_2stage_final_0/m2_nmos_0/a_n956_4256# 0.59234f
C328 sh_final_0/opamp_2stage_final_0/m6_pmos_0/a_52_n16440# sh_final_0/opamp_2stage_final_0/m6_pmos_0/a_356_n16440# 0.05997f
C329 pga_final_0/opamp_2stage_final_0/m4_pmos_0/w_n1220_n4604# pga_final_0/opamp_2stage_final_0/m4_pmos_0/a_52_2256# 0.71938f
C330 sh_final_0/opamp_2stage_final_0/m1_nmos_0/a_452_4348# sh_final_0/opamp_2stage_final_0/m1_nmos_0/a_52_4256# 0.59234f
C331 pga_final_0/opamp_2stage_final_0/m3_pmos_0/a_452_116# pga_final_0/opamp_2stage_final_0/m3_pmos_0/a_556_24# 0.29587f
C332 pga_final_0/opamp_2stage_final_0/m7_nmos_0/a_52_4256# pga_final_0/opamp_2stage_final_0/m7_nmos_0/a_452_4348# 0.59234f
C333 sh_final_0/opamp_2stage_final_0/m3_pmos_0/w_n1220_n4604# sh_final_0/opamp_2stage_final_0/m3_pmos_0/a_n1044_n4348# 1.26104f
C334 pga_final_0/opamp_2stage_final_0/m4_pmos_0/a_52_n4440# pga_final_0/opamp_2stage_final_0/m4_pmos_0/w_n1220_n4604# 0.71938f
C335 sh_final_0/opamp_2stage_final_0/m4_pmos_0/a_n52_n4348# sh_final_0/opamp_2stage_final_0/m4_pmos_0/a_452_n4348# 0.19606f
C336 sh_final_0/opamp_2stage_final_0/m1_nmos_0/a_556_n8440# sh_final_0/opamp_2stage_final_0/m1_nmos_0/a_52_n8440# 0.05997f
C337 pga_final_0/opamp_2stage_final_0/m1_nmos_0/a_n956_24# pga_final_0/opamp_2stage_final_0/m1_nmos_0/a_n956_n4208# 0.37451f
C338 sh_final_0/opamp_2stage_final_0/m5_nmos_0/a_n556_116# sh_final_0/opamp_2stage_final_0/m5_nmos_0/a_n1044_116# 0.19606f
C339 pga_final_0/opamp_2stage_final_0/m2_nmos_0/a_452_4348# pga_final_0/opamp_2stage_final_0/m2_nmos_0/a_n52_4348# 0.39251f
C340 sh_final_0/opamp_2stage_final_0/m4_pmos_0/a_n1044_n4348# sh_final_0/opamp_2stage_final_0/m4_pmos_0/a_n956_n4440# 0.29587f
C341 pga_final_0/opamp_2stage_final_0/m5_nmos_0/a_956_2348# pga_final_0/opamp_2stage_final_0/m5_nmos_0/a_452_2348# 0.19606f
C342 sh_final_0/opamp_2stage_final_0/m6_pmos_0/a_n52_n8116# sh_final_0/opamp_2stage_final_0/m6_pmos_0/a_n252_n8208# 0.85436f
C343 pga_final_0/opamp_2stage_final_0/m6_pmos_0/a_556_n8116# pga_final_0/opamp_2stage_final_0/m6_pmos_0/a_356_n8208# 0.85436f
C344 pga_final_0/opamp_2stage_final_0/m2_nmos_0/a_556_4256# pga_final_0/opamp_2stage_final_0/m2_nmos_0/a_556_24# 0.37451f
C345 pga_final_0/opamp_2stage_final_0/m7_nmos_0/a_n1044_n4116# pga_final_0/opamp_2stage_final_0/m7_nmos_0/a_n556_n4116# 0.39251f
C346 pga_final_0/opamp_2stage_final_0/m3_pmos_0/w_n1220_n4604# pga_final_0/opamp_2stage_final_0/m3_pmos_0/a_n556_2348# 0.47456f
C347 sh_final_0/opamp_2stage_final_0/m3_pmos_0/w_n1220_n4604# sh_final_0/opamp_2stage_final_0/m3_pmos_0/a_452_116# 0.45674f
C348 pga_final_0/opamp_2stage_final_0/m5_nmos_0/a_452_n4348# pga_final_0/opamp_2stage_final_0/m5_nmos_0/a_556_n4440# 0.29587f
C349 pga_final_0/opamp_2stage_final_0/m5_nmos_0/a_n556_n4348# pga_final_0/opamp_2stage_final_0/m5_nmos_0/a_n1044_n4348# 0.19606f
C350 sh_final_0/opamp_2stage_final_0/m7_nmos_0/a_956_116# sh_final_0/opamp_2stage_final_0/m7_nmos_0/a_452_116# 0.39251f
C351 sh_final_0/opamp_2stage_final_0/m2_nmos_0/a_n556_n8348# sh_final_0/opamp_2stage_final_0/m2_nmos_0/a_n1044_n8348# 0.39251f
C352 pga_final_0/opamp_2stage_final_0/m6_pmos_0/a_252_116# pga_final_0/opamp_2stage_final_0/m6_pmos_0/a_52_24# 0.85436f
C353 pga_final_0/opamp_2stage_final_0/m6_pmos_0/a_n556_n8208# pga_final_0/opamp_2stage_final_0/m6_pmos_0/a_n556_24# 0.18596f
C354 pga_final_0/opamp_2stage_final_0/m6_pmos_0/a_n356_116# pga_final_0/opamp_2stage_final_0/m6_pmos_0/a_n644_116# 1.43738f
C355 sh_final_0/opamp_2stage_final_0/m3_pmos_0/a_n956_24# sh_final_0/opamp_2stage_final_0/m3_pmos_0/a_n1044_116# 0.29587f
C356 sh_final_0/opamp_2stage_final_0/m3_pmos_0/a_n1044_2348# sh_final_0/opamp_2stage_final_0/m3_pmos_0/w_n1220_n4604# 1.26104f
C357 sh_final_0/opamp_2stage_final_0/m3_pmos_0/a_n956_n4440# sh_final_0/opamp_2stage_final_0/m3_pmos_0/a_n452_n4440# 0.05997f
C358 pga_final_0/opamp_2stage_final_0/m7_nmos_0/a_556_n8440# pga_final_0/opamp_2stage_final_0/m7_nmos_0/a_452_n8348# 0.59234f
C359 pga_final_0/opamp_2stage_final_0/m2_nmos_0/a_n52_4348# pga_final_0/opamp_2stage_final_0/m2_nmos_0/a_n556_4348# 0.39251f
C360 sh_final_0/opamp_2stage_final_0/m3_pmos_0/a_52_n4440# sh_final_0/opamp_2stage_final_0/m3_pmos_0/a_n52_n4348# 0.29587f
C361 pga_final_0/opamp_2stage_final_0/m1_nmos_0/a_452_n8348# pga_final_0/opamp_2stage_final_0/m1_nmos_0/a_956_n8348# 0.39251f
C362 sh_final_0/opamp_2stage_final_0/m1_nmos_0/a_n452_24# sh_final_0/opamp_2stage_final_0/m1_nmos_0/a_n956_24# 0.05997f
C363 pga_final_0/opamp_2stage_final_0/m5_nmos_0/a_n52_116# pga_final_0/opamp_2stage_final_0/m5_nmos_0/a_52_24# 0.29587f
C364 pga_final_0/opamp_2stage_final_0/m2_nmos_0/a_452_4348# pga_final_0/opamp_2stage_final_0/m2_nmos_0/a_52_4256# 0.59234f
C365 sh_final_0/opamp_2stage_final_0/m3_pmos_0/w_n1220_n4604# sh_final_0/opamp_2stage_final_0/m3_pmos_0/a_52_24# 0.45835f
C366 sh_final_0/opamp_2stage_final_0/m3_pmos_0/a_n956_n2208# sh_final_0/opamp_2stage_final_0/m3_pmos_0/a_n452_n2208# 0.05997f
C367 sh_final_0/opamp_2stage_final_0/m7_nmos_0/a_452_4348# sh_final_0/opamp_2stage_final_0/m7_nmos_0/a_52_4256# 0.59234f
C368 sh_final_0/opamp_2stage_final_0/m6_pmos_0/a_356_8256# sh_final_0/opamp_2stage_final_0/m6_pmos_0/a_52_8256# 0.05997f
C369 pga_final_0/opamp_2stage_final_0/m1_nmos_0/a_n452_n4208# pga_final_0/opamp_2stage_final_0/m1_nmos_0/a_52_n4208# 0.05997f
C370 sh_final_0/opamp_2stage_final_0/m5_nmos_0/a_52_24# sh_final_0/opamp_2stage_final_0/m5_nmos_0/a_52_2256# 0.37451f
C371 pga_final_0/opamp_2stage_final_0/m6_pmos_0/a_52_8256# pga_final_0/opamp_2stage_final_0/m6_pmos_0/a_356_8256# 0.05997f
C372 pga_final_0/opamp_2stage_final_0/m4_pmos_0/w_n1220_n4604# pga_final_0/opamp_2stage_final_0/m4_pmos_0/a_n1044_n4348# 1.26104f
C373 sh_final_0/opamp_2stage_final_0/m2_nmos_0/a_452_116# sh_final_0/opamp_2stage_final_0/m2_nmos_0/a_556_24# 0.59234f
C374 pga_final_0/opamp_2stage_final_0/m5_nmos_0/a_52_n2208# pga_final_0/opamp_2stage_final_0/m5_nmos_0/a_n52_n2116# 0.29587f
C375 sh_final_0/opamp_2stage_final_0/m3_pmos_0/w_n1220_n4604# sh_final_0/opamp_2stage_final_0/m3_pmos_0/a_452_n4348# 0.47456f
C376 pga_final_0/opamp_2stage_final_0/m4_pmos_0/a_452_116# pga_final_0/opamp_2stage_final_0/m4_pmos_0/w_n1220_n4604# 0.45674f
C377 pga_final_0/opamp_2stage_final_0/m4_pmos_0/a_52_2256# pga_final_0/opamp_2stage_final_0/m4_pmos_0/a_n52_2348# 0.29587f
C378 pga_final_0/opamp_2stage_final_0/m2_nmos_0/a_n956_24# pga_final_0/opamp_2stage_final_0/m2_nmos_0/a_n1044_116# 0.59234f
C379 pga_final_0/opamp_2stage_final_0/m5_nmos_0/a_52_n4440# pga_final_0/opamp_2stage_final_0/m5_nmos_0/a_n452_n4440# 0.05997f
C380 pga_final_0/opamp_2stage_final_0/m3_pmos_0/a_n452_n4440# pga_final_0/opamp_2stage_final_0/m3_pmos_0/a_52_n4440# 0.05997f
C381 pga_final_0/opamp_2stage_final_0/m5_nmos_0/a_556_24# pga_final_0/opamp_2stage_final_0/m5_nmos_0/a_556_2256# 0.37451f
C382 sh_final_0/opamp_2stage_final_0/m7_nmos_0/a_n956_24# sh_final_0/opamp_2stage_final_0/m7_nmos_0/a_n956_4256# 0.37451f
C383 sh_final_0/opamp_2stage_final_0/m7_nmos_0/a_n52_n8348# sh_final_0/opamp_2stage_final_0/m7_nmos_0/a_n452_n8440# 0.59234f
C384 sh_final_0/opamp_2stage_final_0/m2_nmos_0/a_52_n8440# sh_final_0/opamp_2stage_final_0/m2_nmos_0/a_n52_n8348# 0.59234f
C385 pga_final_0/opamp_2stage_final_0/m4_pmos_0/a_956_116# pga_final_0/opamp_2stage_final_0/m4_pmos_0/a_556_24# 0.29587f
C386 sh_final_0/opamp_2stage_final_0/m1_nmos_0/a_n956_4256# sh_final_0/opamp_2stage_final_0/m1_nmos_0/a_n956_24# 0.37451f
C387 sh_final_0/opamp_2stage_final_0/m5_nmos_0/a_n956_n2208# sh_final_0/opamp_2stage_final_0/m5_nmos_0/a_n556_n2116# 0.29587f
C388 pga_final_0/opamp_2stage_final_0/m3_pmos_0/a_n956_n4440# pga_final_0/opamp_2stage_final_0/m3_pmos_0/a_n556_n4348# 0.29587f
C389 bias_final_0/bias_nmos_1/a_n540_n1716# bias_final_0/bias_nmos_1/a_n452_n1808# 0.23658f
C390 sh_final_0/opamp_2stage_final_0/m1_nmos_0/a_n52_n8348# sh_final_0/opamp_2stage_final_0/m1_nmos_0/a_452_n8348# 0.39251f
C391 sh_final_0/opamp_2stage_final_0/m2_nmos_0/a_n52_116# sh_final_0/opamp_2stage_final_0/m2_nmos_0/a_n452_24# 0.59234f
C392 pga_final_0/opamp_2stage_final_0/m4_pmos_0/a_n956_n2208# pga_final_0/opamp_2stage_final_0/m4_pmos_0/a_n452_n2208# 0.05997f
C393 pga_final_0/opamp_2stage_final_0/m5_nmos_0/a_n556_n2116# pga_final_0/opamp_2stage_final_0/m5_nmos_0/a_n956_n2208# 0.29587f
C394 sh_final_0/opamp_2stage_final_0/m7_nmos_0/a_n556_n4116# sh_final_0/opamp_2stage_final_0/m7_nmos_0/a_n956_n4208# 0.59234f
C395 pga_final_0/opamp_2stage_final_0/m7_nmos_0/a_n1044_n8348# pga_final_0/opamp_2stage_final_0/m7_nmos_0/a_n556_n8348# 0.39251f
C396 pga_final_0/opamp_2stage_final_0/m4_pmos_0/w_n1220_n4604# pga_final_0/opamp_2stage_final_0/m4_pmos_0/a_n956_n2208# 0.50114f
C397 pga_final_0/opamp_2stage_final_0/m3_pmos_0/w_n1220_n4604# pga_final_0/opamp_2stage_final_0/m3_pmos_0/a_n452_24# 0.45835f
C398 sh_final_0/opamp_2stage_final_0/m2_nmos_0/a_n556_n8348# sh_final_0/opamp_2stage_final_0/m2_nmos_0/a_n52_n8348# 0.39251f
C399 pga_final_0/opamp_2stage_final_0/m5_nmos_0/a_556_24# pga_final_0/opamp_2stage_final_0/m5_nmos_0/a_52_24# 0.05997f
C400 sh_final_0/opamp_2stage_final_0/m4_pmos_0/a_n52_2348# sh_final_0/opamp_2stage_final_0/m4_pmos_0/a_52_2256# 0.29587f
C401 sh_final_0/opamp_2stage_final_0/m4_pmos_0/a_n956_24# sh_final_0/opamp_2stage_final_0/m4_pmos_0/w_n1220_n4604# 0.50114f
C402 sh_final_0/opamp_2stage_final_0/m2_nmos_0/a_52_n4208# sh_final_0/opamp_2stage_final_0/m2_nmos_0/a_n452_n4208# 0.05997f
C403 pga_final_0/opamp_2stage_final_0/m3_pmos_0/w_n1220_n4604# pga_final_0/opamp_2stage_final_0/m3_pmos_0/a_956_n4348# 1.26104f
C404 sh_final_0/opamp_2stage_final_0/m4_pmos_0/a_452_n2116# sh_final_0/opamp_2stage_final_0/m4_pmos_0/a_956_n2116# 0.19606f
C405 sh_final_0/opamp_2stage_final_0/m6_pmos_0/a_556_n8116# sh_final_0/opamp_2stage_final_0/m6_pmos_0/a_356_n8208# 0.85436f
C406 pga_final_0/opamp_2stage_final_0/m1_nmos_0/a_n956_24# pga_final_0/opamp_2stage_final_0/m1_nmos_0/a_n556_116# 0.59234f
C407 pga_final_0/opamp_2stage_final_0/m2_7152_15850# pga_final_0/opamp_2stage_final_0/m6_pmos_0/a_n52_n8116# 0.05541f
C408 sh_final_0/opamp_2stage_final_0/m5_nmos_0/a_52_n2208# sh_final_0/opamp_2stage_final_0/m5_nmos_0/a_52_n4440# 0.37451f
C409 pga_final_0/opamp_2stage_final_0/m3_pmos_0/a_n1044_n2116# pga_final_0/opamp_2stage_final_0/m3_pmos_0/a_n956_n2208# 0.29587f
C410 sh_final_0/opamp_2stage_final_0/m3_pmos_0/a_n452_n2208# sh_final_0/opamp_2stage_final_0/m3_pmos_0/a_n556_n2116# 0.29587f
C411 sh_final_0/opamp_2stage_final_0/m6_pmos_0/a_n356_n8116# sh_final_0/opamp_2stage_final_0/m2_7152_15850# 0.09705f
C412 sh_final_0/opamp_2stage_final_0/m2_nmos_0/a_n452_n8440# sh_final_0/opamp_2stage_final_0/m2_nmos_0/a_n452_n4208# 0.37451f
C413 sh_final_0/opamp_2stage_final_0/m4_pmos_0/a_n452_n2208# sh_final_0/opamp_2stage_final_0/m4_pmos_0/w_n1220_n4604# 0.45835f
C414 pga_final_0/opamp_2stage_final_0/m4_pmos_0/w_n1220_n4604# pga_final_0/opamp_2stage_final_0/m4_pmos_0/a_956_n4348# 1.26104f
C415 sh_final_0/opamp_2stage_final_0/m2_nmos_0/a_52_4256# sh_final_0/opamp_2stage_final_0/m2_nmos_0/a_n452_4256# 0.05997f
C416 pga_final_0/opamp_2stage_final_0/m6_pmos_0/a_52_8256# pga_final_0/opamp_2stage_final_0/m6_pmos_0/a_n252_8256# 0.05997f
C417 pga_final_0/opamp_2stage_final_0/m7_nmos_0/a_556_24# pga_final_0/opamp_2stage_final_0/m7_nmos_0/a_556_4256# 0.37451f
C418 pga_final_0/opamp_2stage_final_0/m5_nmos_0/a_n52_116# pga_final_0/opamp_2stage_final_0/m5_nmos_0/a_452_116# 0.19606f
C419 pga_final_0/opamp_2stage_final_0/m1_nmos_0/a_n956_24# pga_final_0/opamp_2stage_final_0/m1_nmos_0/a_n452_24# 0.05997f
C420 pga_final_0/opamp_2stage_final_0/m5_nmos_0/a_n556_2348# pga_final_0/opamp_2stage_final_0/m5_nmos_0/a_n956_2256# 0.29587f
C421 pga_final_0/opamp_2stage_final_0/m6_pmos_0/a_n356_n8116# pga_final_0/opamp_2stage_final_0/m6_pmos_0/a_n252_n8208# 0.85436f
C422 sh_final_0/opamp_2stage_final_0/m3_pmos_0/a_956_116# sh_final_0/opamp_2stage_final_0/m3_pmos_0/a_452_116# 0.19606f
C423 sh_final_0/opamp_2stage_final_0/m2_nmos_0/a_n956_n8440# sh_final_0/opamp_2stage_final_0/m2_nmos_0/a_n1044_n8348# 0.59234f
C424 sh_final_0/sw_nmos_0/a_n188_n400# sh_final_0/sw_nmos_0/a_n100_n492# 0.08505f
C425 sh_final_0/opamp_2stage_final_0/m5_nmos_0/a_n452_n2208# sh_final_0/opamp_2stage_final_0/m5_nmos_0/a_n452_n4440# 0.37451f
C426 sh_final_0/opamp_2stage_final_0/m5_nmos_0/a_n1044_2348# sh_final_0/opamp_2stage_final_0/m5_nmos_0/a_n556_2348# 0.19606f
C427 pga_final_0/opamp_2stage_final_0/m7_nmos_0/a_52_24# pga_final_0/opamp_2stage_final_0/m7_nmos_0/a_556_24# 0.05997f
C428 sh_final_0/opamp_2stage_final_0/m1_nmos_0/a_n52_n8348# sh_final_0/opamp_2stage_final_0/m1_nmos_0/a_n556_n8348# 0.39251f
C429 pga_final_0/opamp_2stage_final_0/m5_nmos_0/a_956_n2116# pga_final_0/opamp_2stage_final_0/m5_nmos_0/a_452_n2116# 0.19606f
C430 sh_final_0/opamp_2stage_final_0/m4_pmos_0/a_956_116# sh_final_0/opamp_2stage_final_0/m4_pmos_0/a_556_24# 0.29587f
C431 sh_final_0/opamp_2stage_final_0/m4_pmos_0/a_n52_116# sh_final_0/opamp_2stage_final_0/m4_pmos_0/a_n556_116# 0.19606f
C432 sh_final_0/opamp_2stage_final_0/m3_pmos_0/a_n556_2348# sh_final_0/opamp_2stage_final_0/m3_pmos_0/a_n956_2256# 0.29587f
C433 sh_final_0/opamp_2stage_final_0/m6_pmos_0/a_n52_116# sh_final_0/opamp_2stage_final_0/m6_pmos_0/a_52_24# 0.85436f
C434 pga_final_0/opamp_2stage_final_0/m3_pmos_0/a_n52_2348# pga_final_0/opamp_2stage_final_0/m3_pmos_0/a_452_2348# 0.19606f
C435 pga_final_0/opamp_2stage_final_0/m2_nmos_0/a_n452_n8440# pga_final_0/opamp_2stage_final_0/m2_nmos_0/a_n452_n4208# 0.37451f
C436 sh_final_0/opamp_2stage_final_0/m2_nmos_0/a_556_n4208# sh_final_0/opamp_2stage_final_0/m2_nmos_0/a_956_n4116# 0.59234f
C437 pga_final_0/opamp_2stage_final_0/m4_pmos_0/a_n556_2348# pga_final_0/opamp_2stage_final_0/m4_pmos_0/a_n452_2256# 0.29587f
C438 sh_final_0/opamp_2stage_final_0/m1_nmos_0/a_n52_116# sh_final_0/opamp_2stage_final_0/m1_nmos_0/a_n556_116# 0.39251f
C439 sh_final_0/opamp_2stage_final_0/m5_nmos_0/a_452_2348# sh_final_0/opamp_2stage_final_0/m5_nmos_0/a_556_2256# 0.29587f
C440 pga_final_0/opamp_2stage_final_0/m5_nmos_0/a_956_n4348# pga_final_0/opamp_2stage_final_0/m5_nmos_0/a_452_n4348# 0.19606f
C441 pga_final_0/opamp_2stage_final_0/m6_pmos_0/a_n252_24# pga_final_0/opamp_2stage_final_0/m6_pmos_0/a_n556_24# 0.05997f
C442 sh_final_0/opamp_2stage_final_0/m5_nmos_0/a_556_n4440# sh_final_0/opamp_2stage_final_0/m5_nmos_0/a_52_n4440# 0.05997f
C443 sh_final_0/opamp_2stage_final_0/m4_pmos_0/a_n452_24# sh_final_0/opamp_2stage_final_0/m4_pmos_0/a_n956_24# 0.05997f
C444 sh_final_0/opamp_2stage_final_0/m6_pmos_0/a_556_n8116# sh_final_0/opamp_2stage_final_0/m1_n2152_32500# 4.72133f
C445 pga_final_0/opamp_2stage_final_0/m3_pmos_0/a_n452_24# pga_final_0/opamp_2stage_final_0/m3_pmos_0/a_n556_116# 0.29587f
C446 pga_final_0/opamp_2stage_final_0/m7_nmos_0/a_52_n8440# pga_final_0/opamp_2stage_final_0/m7_nmos_0/a_n452_n8440# 0.05997f
C447 pga_final_0/opamp_2stage_final_0/m3_pmos_0/a_n452_24# pga_final_0/opamp_2stage_final_0/m3_pmos_0/a_52_24# 0.05997f
C448 sh_final_0/opamp_2stage_final_0/m5_nmos_0/a_n452_n2208# sh_final_0/opamp_2stage_final_0/m5_nmos_0/a_n52_n2116# 0.29587f
C449 sh_final_0/opamp_2stage_final_0/m4_pmos_0/a_n52_n4348# sh_final_0/opamp_2stage_final_0/m4_pmos_0/a_n556_n4348# 0.19606f
C450 sh_final_0/opamp_2stage_final_0/m5_nmos_0/a_n956_2256# sh_final_0/opamp_2stage_final_0/m5_nmos_0/a_n452_2256# 0.05997f
C451 pga_final_0/opamp_2stage_final_0/m4_pmos_0/a_52_n4440# pga_final_0/opamp_2stage_final_0/m4_pmos_0/a_n52_n4348# 0.29587f
C452 pga_final_0/opamp_2stage_final_0/m3_pmos_0/a_n956_2256# pga_final_0/opamp_2stage_final_0/m3_pmos_0/a_n452_2256# 0.05997f
C453 sh_final_0/opamp_2stage_final_0/m4_pmos_0/a_n956_n2208# sh_final_0/opamp_2stage_final_0/m4_pmos_0/a_n956_24# 0.37451f
C454 sh_final_0/opamp_2stage_final_0/m4_pmos_0/a_n452_n2208# sh_final_0/opamp_2stage_final_0/m4_pmos_0/a_n452_24# 0.37451f
C455 pga_final_0/opamp_2stage_final_0/m3_pmos_0/w_n1220_n4604# pga_final_0/opamp_2stage_final_0/m3_pmos_0/a_n52_116# 0.45673f
C456 sh_final_0/opamp_2stage_final_0/m5_nmos_0/a_452_116# sh_final_0/opamp_2stage_final_0/m5_nmos_0/a_n52_116# 0.19606f
C457 sh_final_0/opamp_2stage_final_0/m5_nmos_0/a_52_24# sh_final_0/opamp_2stage_final_0/m5_nmos_0/a_452_116# 0.29587f
C458 sh_final_0/opamp_2stage_final_0/m1_nmos_0/a_n452_n8440# sh_final_0/opamp_2stage_final_0/m1_nmos_0/a_52_n8440# 0.05997f
C459 sh_final_0/opamp_2stage_final_0/m4_pmos_0/a_52_n4440# sh_final_0/opamp_2stage_final_0/m4_pmos_0/a_52_n2208# 0.37451f
C460 sh_final_0/opamp_2stage_final_0/m1_n2152_32500# sh_final_0/opamp_2stage_final_0/m6_pmos_0/a_n356_n8116# 1.30581f
C461 sh_final_0/opamp_2stage_final_0/m2_nmos_0/a_n52_4348# sh_final_0/opamp_2stage_final_0/m2_nmos_0/a_n452_4256# 0.59234f
C462 pga_final_0/opamp_2stage_final_0/m3_pmos_0/a_956_n2116# pga_final_0/opamp_2stage_final_0/m3_pmos_0/a_556_n2208# 0.29587f
C463 pga_final_0/opamp_2stage_final_0/m5_nmos_0/a_556_24# pga_final_0/opamp_2stage_final_0/m5_nmos_0/a_452_116# 0.29587f
C464 vref_final_0/m2_n100_0# vref_final_0/r_vref_2/a_n200_n1902# 0.07946f
C465 pga_final_0/opamp_2stage_final_0/m3_pmos_0/w_n1220_n4604# pga_final_0/opamp_2stage_final_0/m3_pmos_0/a_n556_n2116# 0.45674f
C466 bias_final_0/bias_nmos_1/a_n540_n1716# bias_final_0/bias_nmos_1/a_n52_n1716# 0.15677f
C467 pga_final_0/opamp_2stage_final_0/m3_pmos_0/a_n452_n4440# pga_final_0/opamp_2stage_final_0/m3_pmos_0/a_n556_n4348# 0.29587f
C468 pga_final_0/opamp_2stage_final_0/m2_nmos_0/a_52_n4208# pga_final_0/opamp_2stage_final_0/m2_nmos_0/a_n52_n4116# 0.59234f
C469 sh_final_0/opamp_2stage_final_0/m4_pmos_0/a_n452_n2208# sh_final_0/opamp_2stage_final_0/m4_pmos_0/a_n956_n2208# 0.05997f
C470 sh_final_0/opamp_2stage_final_0/m2_nmos_0/a_452_116# sh_final_0/opamp_2stage_final_0/m2_nmos_0/a_52_24# 0.59234f
C471 pga_final_0/opamp_2stage_final_0/m4_pmos_0/a_452_116# pga_final_0/opamp_2stage_final_0/m4_pmos_0/a_956_116# 0.19606f
C472 sh_final_0/opamp_2stage_final_0/m3_pmos_0/a_52_n4440# sh_final_0/opamp_2stage_final_0/m3_pmos_0/a_452_n4348# 0.29587f
C473 bias_final_0/bias_nmos_0/a_52_n1808# bias_final_0/bias_nmos_0/a_52_24# 0.37451f
C474 pga_final_0/opamp_2stage_final_0/m1_nmos_0/a_n452_n8440# pga_final_0/opamp_2stage_final_0/m1_nmos_0/a_n452_n4208# 0.37451f
C475 sh_final_0/opamp_2stage_final_0/m6_pmos_0/a_n556_n8208# sh_final_0/opamp_2stage_final_0/m2_7152_15850# 0.08889f
C476 pga_final_0/opamp_2stage_final_0/m7_nmos_0/a_52_24# pga_final_0/opamp_2stage_final_0/m7_nmos_0/a_n452_24# 0.05997f
C477 sh_final_0/opamp_2stage_final_0/m1_nmos_0/a_n556_116# sh_final_0/opamp_2stage_final_0/m1_nmos_0/a_n956_24# 0.59234f
C478 sh_final_0/opamp_2stage_final_0/m4_pmos_0/a_556_n4440# sh_final_0/opamp_2stage_final_0/m4_pmos_0/a_52_n4440# 0.05997f
C479 sh_final_0/opamp_2stage_final_0/m4_pmos_0/a_n556_n4348# sh_final_0/opamp_2stage_final_0/m4_pmos_0/a_n452_n4440# 0.29587f
C480 pga_final_0/opamp_2stage_final_0/m7_nmos_0/a_n956_n8440# pga_final_0/opamp_2stage_final_0/m7_nmos_0/a_n556_n8348# 0.59234f
C481 sh_final_0/opamp_2stage_final_0/m2_nmos_0/a_452_n8348# sh_final_0/opamp_2stage_final_0/m2_nmos_0/a_956_n8348# 0.39251f
C482 sh_final_0/opamp_2stage_final_0/m7_nmos_0/a_n956_n4208# sh_final_0/opamp_2stage_final_0/m7_nmos_0/a_n956_24# 0.37451f
C483 sh_final_0/opamp_2stage_final_0/m4_pmos_0/a_n556_n2116# sh_final_0/opamp_2stage_final_0/m4_pmos_0/a_n452_n2208# 0.29587f
C484 sh_final_0/opamp_2stage_final_0/m4_pmos_0/a_n452_2256# sh_final_0/opamp_2stage_final_0/m4_pmos_0/w_n1220_n4604# 0.71938f
C485 sh_final_0/opamp_2stage_final_0/m2_nmos_0/a_n956_4256# sh_final_0/opamp_2stage_final_0/m2_nmos_0/a_n956_24# 0.37451f
C486 sh_final_0/opamp_2stage_final_0/m2_nmos_0/a_556_24# sh_final_0/opamp_2stage_final_0/m2_nmos_0/a_52_24# 0.05997f
C487 bias_final_0/bias_nmos_1/a_452_n1716# bias_final_0/bias_nmos_1/a_n52_n1716# 0.15677f
C488 sh_final_0/opamp_2stage_final_0/m3_pmos_0/w_n1220_n4604# sh_final_0/opamp_2stage_final_0/m3_pmos_0/a_956_116# 1.24508f
C489 sh_final_0/opamp_2stage_final_0/m5_nmos_0/a_n52_2348# sh_final_0/opamp_2stage_final_0/m5_nmos_0/a_n452_2256# 0.29587f
C490 pga_final_0/opamp_2stage_final_0/m4_pmos_0/w_n1220_n4604# pga_final_0/opamp_2stage_final_0/m4_pmos_0/a_n52_116# 0.45673f
C491 pga_final_0/opamp_2stage_final_0/m2_nmos_0/a_n52_n4116# pga_final_0/opamp_2stage_final_0/m2_nmos_0/a_452_n4116# 0.39251f
C492 sh_final_0/opamp_2stage_final_0/m1_n2152_32500# sh_final_0/opamp_2stage_final_0/m6_pmos_0/a_n252_8256# 2.53966f
C493 sh_final_0/opamp_2stage_final_0/m1_nmos_0/a_556_n4208# sh_final_0/opamp_2stage_final_0/m1_nmos_0/a_52_n4208# 0.05997f
C494 sh_final_0/opamp_2stage_final_0/m2_nmos_0/a_452_4348# sh_final_0/opamp_2stage_final_0/m2_nmos_0/a_556_4256# 0.59234f
C495 pga_final_0/opamp_2stage_final_0/m6_pmos_0/a_52_n16440# pga_final_0/opamp_2stage_final_0/m6_pmos_0/a_n252_n16440# 0.05997f
C496 sh_final_0/opamp_2stage_final_0/m6_pmos_0/a_n556_24# sh_final_0/opamp_2stage_final_0/m6_pmos_0/a_n356_116# 0.85436f
C497 pga_final_0/opamp_2stage_final_0/m4_pmos_0/a_n556_116# pga_final_0/opamp_2stage_final_0/m4_pmos_0/a_n52_116# 0.19606f
C498 pga_final_0/opamp_2stage_final_0/m3_pmos_0/a_n52_116# pga_final_0/opamp_2stage_final_0/m3_pmos_0/a_n556_116# 0.19606f
C499 sh_final_0/opamp_2stage_final_0/m7_nmos_0/a_n452_4256# sh_final_0/opamp_2stage_final_0/m7_nmos_0/a_n556_4348# 0.59234f
C500 sh_final_0/opamp_2stage_final_0/m3_pmos_0/a_n956_2256# sh_final_0/opamp_2stage_final_0/m3_pmos_0/a_n452_2256# 0.05997f
C501 pga_final_0/opamp_2stage_final_0/m3_pmos_0/a_n52_116# pga_final_0/opamp_2stage_final_0/m3_pmos_0/a_52_24# 0.29587f
C502 sh_final_0/opamp_2stage_final_0/m3_pmos_0/w_n1220_n4604# sh_final_0/opamp_2stage_final_0/m3_pmos_0/a_556_2256# 0.76217f
C503 sh_final_0/opamp_2stage_final_0/m2_nmos_0/a_556_n4208# sh_final_0/opamp_2stage_final_0/m2_nmos_0/a_452_n4116# 0.59234f
C504 sh_final_0/opamp_2stage_final_0/m6_pmos_0/a_52_n8208# sh_final_0/opamp_2stage_final_0/m6_pmos_0/a_n52_n8116# 0.85436f
C505 sh_final_0/opamp_2stage_final_0/m5_nmos_0/a_956_n4348# sh_final_0/opamp_2stage_final_0/m5_nmos_0/a_452_n4348# 0.19606f
C506 sh_final_0/opamp_2stage_final_0/m3_pmos_0/a_52_n4440# sh_final_0/opamp_2stage_final_0/m3_pmos_0/w_n1220_n4604# 0.71938f
C507 pga_final_0/opamp_2stage_final_0/m3_pmos_0/w_n1220_n4604# pga_final_0/opamp_2stage_final_0/m3_pmos_0/a_52_n2208# 0.45835f
C508 pga_final_0/opamp_2stage_final_0/m1_nmos_0/a_956_4348# pga_final_0/opamp_2stage_final_0/m1_nmos_0/a_556_4256# 0.59234f
C509 sh_final_0/opamp_2stage_final_0/m4_pmos_0/a_452_n2116# sh_final_0/opamp_2stage_final_0/m4_pmos_0/a_52_n2208# 0.29587f
C510 bias_final_0/bias_nmos_1/a_n452_n1808# bias_final_0/bias_nmos_1/a_n452_24# 0.37451f
C511 sh_final_0/opamp_2stage_final_0/m4_pmos_0/a_n956_n4440# sh_final_0/opamp_2stage_final_0/m4_pmos_0/w_n1220_n4604# 0.76217f
C512 sh_final_0/opamp_2stage_final_0/m5_nmos_0/a_52_2256# sh_final_0/opamp_2stage_final_0/m5_nmos_0/a_n452_2256# 0.05997f
C513 pga_final_0/opamp_2stage_final_0/m3_pmos_0/w_n1220_n4604# pga_final_0/opamp_2stage_final_0/m3_pmos_0/a_n452_2256# 0.71938f
C514 sh_final_0/opamp_2stage_final_0/m3_pmos_0/a_452_n2116# sh_final_0/opamp_2stage_final_0/m3_pmos_0/a_556_n2208# 0.29587f
C515 sh_final_0/opamp_2stage_final_0/m6_pmos_0/a_n556_n8208# sh_final_0/opamp_2stage_final_0/m1_n2152_32500# 0.29128f
C516 sh_final_0/opamp_2stage_final_0/m3_pmos_0/a_452_n2116# sh_final_0/opamp_2stage_final_0/m3_pmos_0/a_956_n2116# 0.19606f
C517 sh_final_0/opamp_2stage_final_0/m4_pmos_0/a_956_2348# sh_final_0/opamp_2stage_final_0/m4_pmos_0/a_556_2256# 0.29587f
C518 sh_final_0/opamp_2stage_final_0/m4_pmos_0/a_n452_24# sh_final_0/opamp_2stage_final_0/m4_pmos_0/a_n452_2256# 0.37451f
C519 sh_final_0/opamp_2stage_final_0/m4_pmos_0/a_n52_2348# sh_final_0/opamp_2stage_final_0/m4_pmos_0/a_n556_2348# 0.19606f
C520 sh_final_0/opamp_2stage_final_0/m4_pmos_0/a_556_n4440# sh_final_0/opamp_2stage_final_0/m4_pmos_0/a_452_n4348# 0.29587f
C521 sh_final_0/opamp_2stage_final_0/m1_nmos_0/a_556_4256# sh_final_0/opamp_2stage_final_0/m1_nmos_0/a_52_4256# 0.05997f
C522 pga_final_0/opamp_2stage_final_0/m6_pmos_0/a_n252_24# pga_final_0/opamp_2stage_final_0/m6_pmos_0/a_n252_8256# 0.18596f
C523 pga_final_0/opamp_2stage_final_0/m2_nmos_0/a_n452_24# pga_final_0/opamp_2stage_final_0/m2_nmos_0/a_n556_116# 0.59234f
C524 pga_final_0/opamp_2stage_final_0/m7_nmos_0/a_452_n8348# pga_final_0/opamp_2stage_final_0/m7_nmos_0/a_n52_n8348# 0.39251f
C525 sh_final_0/opamp_2stage_final_0/m1_nmos_0/a_556_n8440# sh_final_0/opamp_2stage_final_0/m1_nmos_0/a_956_n8348# 0.59234f
C526 sh_final_0/opamp_2stage_final_0/m5_nmos_0/a_52_24# sh_final_0/opamp_2stage_final_0/m5_nmos_0/a_n52_116# 0.29587f
C527 sh_final_0/opamp_2stage_final_0/m6_pmos_0/a_n252_8256# sh_final_0/opamp_2stage_final_0/m6_pmos_0/a_n252_24# 0.18596f
C528 pga_final_0/opamp_2stage_final_0/m4_pmos_0/a_n1044_n2116# pga_final_0/opamp_2stage_final_0/m4_pmos_0/a_n956_n2208# 0.29587f
C529 pga_final_0/opamp_2stage_final_0/m7_nmos_0/a_n556_4348# pga_final_0/opamp_2stage_final_0/m7_nmos_0/a_n1044_4348# 0.39251f
C530 sh_final_0/opamp_2stage_final_0/m4_pmos_0/a_556_n2208# sh_final_0/opamp_2stage_final_0/m4_pmos_0/w_n1220_n4604# 0.50114f
C531 sh_final_0/opamp_2stage_final_0/m2_nmos_0/a_n556_4348# sh_final_0/opamp_2stage_final_0/m2_nmos_0/a_n452_4256# 0.59234f
C532 sh_final_0/opamp_2stage_final_0/m3_pmos_0/a_n956_24# sh_final_0/opamp_2stage_final_0/m3_pmos_0/w_n1220_n4604# 0.50114f
C533 pga_final_0/opamp_2stage_final_0/m6_pmos_0/a_n556_n16440# pga_final_0/opamp_2stage_final_0/m6_pmos_0/a_n556_n8208# 0.18596f
C534 sh_final_0/opamp_2stage_final_0/m7_nmos_0/a_956_4348# sh_final_0/opamp_2stage_final_0/m7_nmos_0/a_556_4256# 0.59234f
C535 pga_final_0/opamp_2stage_final_0/m3_pmos_0/a_n956_n4440# pga_final_0/opamp_2stage_final_0/m3_pmos_0/a_n452_n4440# 0.05997f
C536 sh_final_0/opamp_2stage_final_0/m7_nmos_0/a_52_24# sh_final_0/opamp_2stage_final_0/m7_nmos_0/a_52_n4208# 0.37451f
C537 pga_final_0/opamp_2stage_final_0/m3_pmos_0/a_n956_2256# pga_final_0/opamp_2stage_final_0/m3_pmos_0/a_n956_24# 0.37451f
C538 pga_final_0/opamp_2stage_final_0/m2_nmos_0/a_52_24# pga_final_0/opamp_2stage_final_0/m2_nmos_0/a_52_4256# 0.37451f
C539 bias_final_0/bias_nmos_1/a_52_n1808# bias_final_0/bias_nmos_1/a_52_24# 0.37451f
C540 pga_final_0/opamp_2stage_final_0/m4_pmos_0/a_52_24# pga_final_0/opamp_2stage_final_0/m4_pmos_0/a_n452_24# 0.05997f
C541 sh_final_0/opamp_2stage_final_0/m6_pmos_0/a_52_24# sh_final_0/opamp_2stage_final_0/m6_pmos_0/a_252_116# 0.85436f
C542 pga_final_0/opamp_2stage_final_0/m6_pmos_0/a_52_n16440# pga_final_0/opamp_2stage_final_0/m6_pmos_0/a_356_n16440# 0.05997f
C543 pga_final_0/opamp_2stage_final_0/m6_pmos_0/a_n644_116# pga_final_0/opamp_2stage_final_0/m6_pmos_0/a_n556_24# 0.85436f
C544 pga_final_0/opamp_2stage_final_0/m7_nmos_0/a_n956_4256# pga_final_0/opamp_2stage_final_0/m7_nmos_0/a_n452_4256# 0.05997f
C545 sh_final_0/opamp_2stage_final_0/m7_nmos_0/a_n52_4348# sh_final_0/opamp_2stage_final_0/m7_nmos_0/a_n556_4348# 0.39251f
C546 sh_final_0/opamp_2stage_final_0/m2_nmos_0/a_556_n4208# sh_final_0/opamp_2stage_final_0/m2_nmos_0/a_556_24# 0.37451f
C547 pga_final_0/opamp_2stage_final_0/m3_pmos_0/a_52_n2208# pga_final_0/opamp_2stage_final_0/m3_pmos_0/a_52_24# 0.37451f
C548 sh_final_0/opamp_2stage_final_0/m4_pmos_0/a_n1044_116# sh_final_0/opamp_2stage_final_0/m4_pmos_0/w_n1220_n4604# 1.24508f
C549 sh_final_0/opamp_2stage_final_0/m3_pmos_0/a_n1044_116# sh_final_0/opamp_2stage_final_0/m3_pmos_0/a_n556_116# 0.19606f
C550 sh_final_0/opamp_2stage_final_0/m1_nmos_0/a_556_24# sh_final_0/opamp_2stage_final_0/m1_nmos_0/a_556_4256# 0.37451f
C551 sh_final_0/opamp_2stage_final_0/m4_pmos_0/a_n956_n4440# sh_final_0/opamp_2stage_final_0/m4_pmos_0/a_n956_n2208# 0.37451f
C552 pga_final_0/opamp_2stage_final_0/m3_pmos_0/w_n1220_n4604# pga_final_0/opamp_2stage_final_0/m3_pmos_0/a_452_n2116# 0.45674f
C553 pga_final_0/opamp_2stage_final_0/m3_pmos_0/a_n1044_116# pga_final_0/opamp_2stage_final_0/m3_pmos_0/a_n956_24# 0.29587f
C554 pga_final_0/opamp_2stage_final_0/m4_pmos_0/a_n452_n4440# pga_final_0/opamp_2stage_final_0/m4_pmos_0/a_n452_n2208# 0.37451f
C555 pga_final_0/opamp_2stage_final_0/m3_pmos_0/a_452_n4348# pga_final_0/opamp_2stage_final_0/m3_pmos_0/a_956_n4348# 0.19606f
C556 pga_final_0/opamp_2stage_final_0/m7_nmos_0/a_52_4256# pga_final_0/opamp_2stage_final_0/m7_nmos_0/a_n52_4348# 0.59234f
C557 sh_final_0/opamp_2stage_final_0/m1_nmos_0/a_956_n4116# sh_final_0/opamp_2stage_final_0/m1_nmos_0/a_452_n4116# 0.39251f
C558 sh_final_0/opamp_2stage_final_0/m1_n2152_32500# sh_final_0/opamp_2stage_final_0/m2_14000_34400# 39.93953f
C559 sh_final_0/opamp_2stage_final_0/m7_nmos_0/a_n556_n4116# sh_final_0/opamp_2stage_final_0/m7_nmos_0/a_n452_n4208# 0.59234f
C560 sh_final_0/opamp_2stage_final_0/m7_nmos_0/a_52_n8440# sh_final_0/opamp_2stage_final_0/m7_nmos_0/a_452_n8348# 0.59234f
C561 pga_final_0/opamp_2stage_final_0/m4_pmos_0/w_n1220_n4604# pga_final_0/opamp_2stage_final_0/m4_pmos_0/a_n452_n4440# 0.71938f
C562 sh_final_0/opamp_2stage_final_0/m2_nmos_0/a_n1044_4348# sh_final_0/opamp_2stage_final_0/m2_nmos_0/a_n956_4256# 0.59234f
C563 pga_final_0/opamp_2stage_final_0/m7_nmos_0/a_n1044_n8348# pga_final_0/opamp_2stage_final_0/m7_nmos_0/a_n956_n8440# 0.59234f
C564 pga_final_0/opamp_2stage_final_0/m5_nmos_0/a_n452_24# pga_final_0/opamp_2stage_final_0/m5_nmos_0/a_52_24# 0.05997f
C565 pga_final_0/opamp_2stage_final_0/m6_pmos_0/a_252_n8116# pga_final_0/opamp_2stage_final_0/m6_pmos_0/a_n52_n8116# 1.43738f
C566 sh_final_0/opamp_2stage_final_0/m1_nmos_0/a_n52_4348# sh_final_0/opamp_2stage_final_0/m1_nmos_0/a_52_4256# 0.59234f
C567 sh_final_0/opamp_2stage_final_0/m3_pmos_0/a_452_n2116# sh_final_0/opamp_2stage_final_0/m3_pmos_0/a_52_n2208# 0.29587f
C568 sh_final_0/opamp_2stage_final_0/m7_nmos_0/a_452_4348# sh_final_0/opamp_2stage_final_0/m7_nmos_0/a_956_4348# 0.39251f
C569 pga_final_0/opamp_2stage_final_0/m5_nmos_0/a_n52_2348# pga_final_0/opamp_2stage_final_0/m5_nmos_0/a_n452_2256# 0.29587f
C570 sh_final_0/opamp_2stage_final_0/m3_pmos_0/a_n556_2348# sh_final_0/opamp_2stage_final_0/m3_pmos_0/a_n52_2348# 0.19606f
C571 sh_final_0/opamp_2stage_final_0/m5_nmos_0/a_n1044_116# sh_final_0/opamp_2stage_final_0/m5_nmos_0/a_n956_24# 0.29587f
C572 pga_final_0/opamp_2stage_final_0/m3_pmos_0/w_n1220_n4604# pga_final_0/opamp_2stage_final_0/m3_pmos_0/a_556_2256# 0.76217f
C573 pga_final_0/opamp_2stage_final_0/m1_nmos_0/a_n956_n8440# pga_final_0/opamp_2stage_final_0/m1_nmos_0/a_n556_n8348# 0.59234f
C574 pga_final_0/opamp_2stage_final_0/m1_nmos_0/a_n52_4348# pga_final_0/opamp_2stage_final_0/m1_nmos_0/a_52_4256# 0.59234f
C575 pga_final_0/opamp_2stage_final_0/m6_pmos_0/a_556_116# pga_final_0/opamp_2stage_final_0/m6_pmos_0/a_252_116# 1.43738f
C576 pga_final_0/opamp_2stage_final_0/m1_nmos_0/a_n956_4256# pga_final_0/opamp_2stage_final_0/m1_nmos_0/a_n1044_4348# 0.59234f
C577 sh_final_0/opamp_2stage_final_0/m4_pmos_0/a_n556_116# sh_final_0/opamp_2stage_final_0/m4_pmos_0/a_n956_24# 0.29587f
C578 pga_final_0/opamp_2stage_final_0/m7_nmos_0/a_n452_4256# pga_final_0/opamp_2stage_final_0/m7_nmos_0/a_n52_4348# 0.59234f
C579 sh_final_0/opamp_2stage_final_0/m1_nmos_0/a_n556_4348# sh_final_0/opamp_2stage_final_0/m1_nmos_0/a_n1044_4348# 0.39251f
C580 sh_final_0/opamp_2stage_final_0/m1_nmos_0/a_n956_n4208# sh_final_0/opamp_2stage_final_0/m1_nmos_0/a_n956_24# 0.37451f
C581 sh_final_0/opamp_2stage_final_0/m1_nmos_0/a_452_116# sh_final_0/opamp_2stage_final_0/m1_nmos_0/a_52_24# 0.59234f
C582 sh_final_0/opamp_2stage_final_0/m3_pmos_0/a_n452_n2208# sh_final_0/opamp_2stage_final_0/m3_pmos_0/a_n452_n4440# 0.37451f
C583 sh_final_0/opamp_2stage_final_0/m7_nmos_0/a_52_n4208# sh_final_0/opamp_2stage_final_0/m7_nmos_0/a_452_n4116# 0.59234f
C584 pga_final_0/opamp_2stage_final_0/m2_nmos_0/a_n556_n8348# pga_final_0/opamp_2stage_final_0/m2_nmos_0/a_n956_n8440# 0.59234f
C585 sh_final_0/opamp_2stage_final_0/m4_pmos_0/a_n1044_2348# sh_final_0/opamp_2stage_final_0/m4_pmos_0/w_n1220_n4604# 1.26104f
C586 sh_final_0/opamp_2stage_final_0/m4_pmos_0/a_n452_n4440# sh_final_0/opamp_2stage_final_0/m4_pmos_0/a_n452_n2208# 0.37451f
C587 sh_final_0/opamp_2stage_final_0/m4_pmos_0/a_52_2256# sh_final_0/opamp_2stage_final_0/m4_pmos_0/a_n452_2256# 0.05997f
C588 sh_final_0/opamp_2stage_final_0/m3_pmos_0/a_52_2256# sh_final_0/opamp_2stage_final_0/m3_pmos_0/a_n52_2348# 0.29587f
C589 sh_final_0/opamp_2stage_final_0/m2_nmos_0/a_n556_n8348# sh_final_0/opamp_2stage_final_0/m2_nmos_0/a_n956_n8440# 0.59234f
C590 sh_final_0/opamp_2stage_final_0/m3_pmos_0/a_n52_116# sh_final_0/opamp_2stage_final_0/m3_pmos_0/a_452_116# 0.19606f
C591 pga_final_0/opamp_2stage_final_0/m3_pmos_0/w_n1220_n4604# pga_final_0/opamp_2stage_final_0/m3_pmos_0/a_n956_24# 0.50114f
C592 pga_final_0/opamp_2stage_final_0/m2_nmos_0/a_556_n8440# pga_final_0/opamp_2stage_final_0/m2_nmos_0/a_556_n4208# 0.37451f
C593 pga_final_0/opamp_2stage_final_0/m7_nmos_0/a_n52_4348# pga_final_0/opamp_2stage_final_0/m7_nmos_0/a_452_4348# 0.39251f
C594 sh_final_0/opamp_2stage_final_0/m1_nmos_0/a_n556_4348# sh_final_0/opamp_2stage_final_0/m1_nmos_0/a_n452_4256# 0.59234f
C595 sh_final_0/opamp_2stage_final_0/m1_nmos_0/a_556_n8440# sh_final_0/opamp_2stage_final_0/m1_nmos_0/a_556_n4208# 0.37451f
C596 pga_final_0/opamp_2stage_final_0/m3_pmos_0/w_n1220_n4604# pga_final_0/opamp_2stage_final_0/m3_pmos_0/a_556_n4440# 0.76217f
C597 bias_final_0/bias_nmos_1/a_52_n1808# bias_final_0/bias_nmos_1/a_452_n1716# 0.23658f
C598 sh_final_0/opamp_2stage_final_0/m5_nmos_0/a_556_24# sh_final_0/opamp_2stage_final_0/m5_nmos_0/a_556_2256# 0.37451f
C599 pga_final_0/opamp_2stage_final_0/m5_nmos_0/a_n956_n4440# pga_final_0/opamp_2stage_final_0/m5_nmos_0/a_n452_n4440# 0.05997f
C600 sh_final_0/opamp_2stage_final_0/m3_pmos_0/a_n52_116# sh_final_0/opamp_2stage_final_0/m3_pmos_0/a_52_24# 0.29587f
C601 sh_final_0/opamp_2stage_final_0/m7_nmos_0/a_n1044_4348# sh_final_0/opamp_2stage_final_0/m7_nmos_0/a_n956_4256# 0.59234f
C602 sh_final_0/opamp_2stage_final_0/m7_nmos_0/a_n956_n8440# sh_final_0/opamp_2stage_final_0/m7_nmos_0/a_n452_n8440# 0.05997f
C603 pga_final_0/opamp_2stage_final_0/m5_nmos_0/a_452_n2116# pga_final_0/opamp_2stage_final_0/m5_nmos_0/a_556_n2208# 0.29587f
C604 pga_final_0/opamp_2stage_final_0/m2_nmos_0/a_52_n4208# pga_final_0/opamp_2stage_final_0/m2_nmos_0/a_452_n4116# 0.59234f
C605 sh_final_0/opamp_2stage_final_0/m4_pmos_0/a_n1044_n4348# sh_final_0/opamp_2stage_final_0/m4_pmos_0/w_n1220_n4604# 1.26104f
C606 pga_final_0/opamp_2stage_final_0/m1_nmos_0/a_52_4256# pga_final_0/opamp_2stage_final_0/m1_nmos_0/a_556_4256# 0.05997f
C607 sh_final_0/opamp_2stage_final_0/m7_nmos_0/a_956_n8348# sh_final_0/opamp_2stage_final_0/m7_nmos_0/a_452_n8348# 0.39251f
C608 sh_final_0/opamp_2stage_final_0/m2_nmos_0/a_n452_n8440# sh_final_0/opamp_2stage_final_0/m2_nmos_0/a_n52_n8348# 0.59234f
C609 pga_final_0/opamp_2stage_final_0/m5_nmos_0/a_52_2256# pga_final_0/opamp_2stage_final_0/m5_nmos_0/a_n452_2256# 0.05997f
C610 pga_final_0/opamp_2stage_final_0/m7_nmos_0/a_n556_116# pga_final_0/opamp_2stage_final_0/m7_nmos_0/a_n1044_116# 0.39251f
C611 pga_final_0/opamp_2stage_final_0/m2_nmos_0/a_n52_n8348# pga_final_0/opamp_2stage_final_0/m2_nmos_0/a_52_n8440# 0.59234f
C612 sh_final_0/opamp_2stage_final_0/m3_pmos_0/a_n452_24# sh_final_0/opamp_2stage_final_0/m3_pmos_0/a_n452_n2208# 0.37451f
C613 sh_final_0/opamp_2stage_final_0/m1_n2152_32500# sh_final_0/opamp_2stage_final_0/m6_pmos_0/a_52_n16440# 2.20123f
C614 pga_final_0/opamp_2stage_final_0/m1_nmos_0/a_n956_4256# pga_final_0/opamp_2stage_final_0/m1_nmos_0/a_n956_24# 0.37451f
C615 pga_final_0/opamp_2stage_final_0/m1_nmos_0/a_n556_n8348# pga_final_0/opamp_2stage_final_0/m1_nmos_0/a_n1044_n8348# 0.39251f
C616 sh_final_0/opamp_2stage_final_0/m1_n2152_32500# sh_final_0/opamp_2stage_final_0/m6_pmos_0/a_52_8256# 2.53966f
C617 pga_final_0/opamp_2stage_final_0/m3_pmos_0/w_n1220_n4604# pga_final_0/opamp_2stage_final_0/m3_pmos_0/a_556_24# 0.50114f
C618 pga_final_0/opamp_2stage_final_0/m7_nmos_0/a_956_n4116# pga_final_0/opamp_2stage_final_0/m7_nmos_0/a_452_n4116# 0.39251f
C619 sh_final_0/opamp_2stage_final_0/m7_nmos_0/a_556_n4208# sh_final_0/opamp_2stage_final_0/m7_nmos_0/a_52_n4208# 0.05997f
C620 sh_final_0/opamp_2stage_final_0/m5_nmos_0/a_n452_n4440# sh_final_0/opamp_2stage_final_0/m5_nmos_0/a_52_n4440# 0.05997f
C621 sh_final_0/opamp_2stage_final_0/m7_nmos_0/a_52_24# sh_final_0/opamp_2stage_final_0/m7_nmos_0/a_556_24# 0.05997f
C622 pga_final_0/opamp_2stage_final_0/m4_pmos_0/w_n1220_n4604# pga_final_0/opamp_2stage_final_0/m4_pmos_0/a_n956_n4440# 0.76217f
C623 pga_final_0/opamp_2stage_final_0/m4_pmos_0/a_n956_24# pga_final_0/opamp_2stage_final_0/m4_pmos_0/a_n956_n2208# 0.37451f
C624 pga_final_0/opamp_2stage_final_0/m4_pmos_0/a_n556_2348# pga_final_0/opamp_2stage_final_0/m4_pmos_0/w_n1220_n4604# 0.47456f
C625 pga_final_0/opamp_2stage_final_0/m4_pmos_0/a_52_n2208# pga_final_0/opamp_2stage_final_0/m4_pmos_0/a_52_24# 0.37451f
C626 pga_final_0/opamp_2stage_final_0/m3_pmos_0/a_n556_116# pga_final_0/opamp_2stage_final_0/m3_pmos_0/a_n956_24# 0.29587f
C627 pga_final_0/opamp_2stage_final_0/m7_nmos_0/a_556_n4208# pga_final_0/opamp_2stage_final_0/m7_nmos_0/a_956_n4116# 0.59234f
C628 sh_final_0/opamp_2stage_final_0/m1_n2152_32500# sh_final_0/opamp_2stage_final_0/m6_pmos_0/a_n556_24# 0.29156f
C629 pga_final_0/opamp_2stage_final_0/m1_nmos_0/a_556_24# pga_final_0/opamp_2stage_final_0/m1_nmos_0/a_556_4256# 0.37451f
C630 sh_final_0/opamp_2stage_final_0/m6_pmos_0/a_52_n16440# sh_final_0/opamp_2stage_final_0/m6_pmos_0/a_n252_n16440# 0.05997f
C631 sh_final_0/opamp_2stage_final_0/m3_pmos_0/a_n452_2256# sh_final_0/opamp_2stage_final_0/m3_pmos_0/a_n52_2348# 0.29587f
C632 pga_final_0/opamp_2stage_final_0/m6_pmos_0/a_252_n8116# pga_final_0/opamp_2stage_final_0/m6_pmos_0/a_52_n8208# 0.85436f
C633 pga_final_0/opamp_2stage_final_0/m2_nmos_0/a_556_n8440# pga_final_0/opamp_2stage_final_0/m2_nmos_0/a_52_n8440# 0.05997f
C634 pga_final_0/opamp_2stage_final_0/m2_nmos_0/a_n52_4348# pga_final_0/opamp_2stage_final_0/m2_nmos_0/a_n452_4256# 0.59234f
C635 pga_final_0/opamp_2stage_final_0/m1_nmos_0/a_52_24# pga_final_0/opamp_2stage_final_0/m1_nmos_0/a_n452_24# 0.05997f
C636 pga_final_0/opamp_2stage_final_0/m5_nmos_0/a_n556_n4348# pga_final_0/opamp_2stage_final_0/m5_nmos_0/a_n452_n4440# 0.29587f
C637 pga_final_0/opamp_2stage_final_0/m4_pmos_0/a_956_2348# pga_final_0/opamp_2stage_final_0/m4_pmos_0/a_556_2256# 0.29587f
C638 pga_final_0/opamp_2stage_final_0/m4_pmos_0/a_52_n2208# pga_final_0/opamp_2stage_final_0/m4_pmos_0/a_52_n4440# 0.37451f
C639 sh_final_0/opamp_2stage_final_0/m1_nmos_0/a_n1044_n8348# sh_final_0/opamp_2stage_final_0/m1_nmos_0/a_n556_n8348# 0.39251f
C640 pga_final_0/opamp_2stage_final_0/m2_nmos_0/a_556_n4208# pga_final_0/opamp_2stage_final_0/m2_nmos_0/a_52_n4208# 0.05997f
C641 pga_final_0/opamp_2stage_final_0/m2_nmos_0/a_956_n8348# pga_final_0/opamp_2stage_final_0/m2_nmos_0/a_556_n8440# 0.59234f
C642 pga_final_0/opamp_2stage_final_0/m3_pmos_0/a_52_n2208# pga_final_0/opamp_2stage_final_0/m3_pmos_0/a_52_n4440# 0.37451f
C643 sh_final_0/opamp_2stage_final_0/m7_nmos_0/a_n52_4348# sh_final_0/opamp_2stage_final_0/m7_nmos_0/a_n452_4256# 0.59234f
C644 sh_final_0/opamp_2stage_final_0/m6_pmos_0/a_252_n8116# sh_final_0/opamp_2stage_final_0/m6_pmos_0/a_52_n8208# 0.85436f
C645 pga_final_0/opamp_2stage_final_0/m6_pmos_0/a_n52_116# pga_final_0/opamp_2stage_final_0/m6_pmos_0/a_n252_24# 0.85436f
C646 sh_final_0/opamp_2stage_final_0/m2_nmos_0/a_52_24# sh_final_0/opamp_2stage_final_0/m2_nmos_0/a_52_4256# 0.37451f
C647 pga_final_0/opamp_2stage_final_0/m7_nmos_0/a_n956_4256# pga_final_0/opamp_2stage_final_0/m7_nmos_0/a_n956_24# 0.37451f
C648 sh_final_0/opamp_2stage_final_0/m5_nmos_0/a_956_116# sh_final_0/opamp_2stage_final_0/m5_nmos_0/a_556_24# 0.29587f
C649 sh_final_0/opamp_2stage_final_0/m7_nmos_0/a_n452_n4208# sh_final_0/opamp_2stage_final_0/m7_nmos_0/a_n452_24# 0.37451f
C650 sh_final_0/opamp_2stage_final_0/m4_pmos_0/a_452_116# sh_final_0/opamp_2stage_final_0/m4_pmos_0/w_n1220_n4604# 0.45674f
C651 sh_final_0/opamp_2stage_final_0/m4_pmos_0/a_556_24# sh_final_0/opamp_2stage_final_0/m4_pmos_0/a_556_2256# 0.37451f
C652 sh_final_0/opamp_2stage_final_0/m3_pmos_0/w_n1220_n4604# sh_final_0/opamp_2stage_final_0/m3_pmos_0/a_n52_116# 0.45673f
C653 pga_final_0/opamp_2stage_final_0/m4_pmos_0/a_n556_n4348# pga_final_0/opamp_2stage_final_0/m4_pmos_0/a_n1044_n4348# 0.19606f
C654 bias_final_0/bias_nmos_0/a_n452_24# bias_final_0/bias_nmos_0/a_n52_116# 0.23658f
C655 pga_final_0/opamp_2stage_final_0/m1_nmos_0/a_n1044_4348# pga_final_0/opamp_2stage_final_0/m1_nmos_0/a_n556_4348# 0.39251f
C656 sh_final_0/opamp_2stage_final_0/m5_nmos_0/a_n452_n4440# sh_final_0/opamp_2stage_final_0/m5_nmos_0/a_n52_n4348# 0.29587f
C657 pga_final_0/opamp_2stage_final_0/m5_nmos_0/a_n52_n4348# pga_final_0/opamp_2stage_final_0/m5_nmos_0/a_452_n4348# 0.19606f
C658 sh_final_0/opamp_2stage_final_0/m1_nmos_0/a_n1044_116# sh_final_0/opamp_2stage_final_0/m1_nmos_0/a_n556_116# 0.39251f
C659 pga_final_0/opamp_2stage_final_0/m2_nmos_0/a_n452_4256# pga_final_0/opamp_2stage_final_0/m2_nmos_0/a_52_4256# 0.05997f
C660 pga_final_0/opamp_2stage_final_0/m3_pmos_0/w_n1220_n4604# pga_final_0/opamp_2stage_final_0/m3_pmos_0/a_452_116# 0.45674f
C661 sh_final_0/opamp_2stage_final_0/m3_pmos_0/w_n1220_n4604# sh_final_0/opamp_2stage_final_0/m3_pmos_0/a_956_2348# 1.26104f
C662 pga_final_0/opamp_2stage_final_0/m7_nmos_0/a_52_n8440# pga_final_0/opamp_2stage_final_0/m7_nmos_0/a_452_n8348# 0.59234f
C663 pga_final_0/opamp_2stage_final_0/m4_pmos_0/a_n556_n2116# pga_final_0/opamp_2stage_final_0/m4_pmos_0/a_n452_n2208# 0.29587f
C664 pga_final_0/opamp_2stage_final_0/m3_pmos_0/a_52_2256# pga_final_0/opamp_2stage_final_0/m3_pmos_0/w_n1220_n4604# 0.71938f
C665 sh_final_0/opamp_2stage_final_0/m6_pmos_0/a_n556_24# sh_final_0/opamp_2stage_final_0/m6_pmos_0/a_n252_24# 0.05997f
C666 sh_final_0/opamp_2stage_final_0/m3_pmos_0/a_n52_n2116# sh_final_0/opamp_2stage_final_0/m3_pmos_0/a_n556_n2116# 0.19606f
C667 sh_final_0/opamp_2stage_final_0/m6_pmos_0/a_252_n8116# sh_final_0/opamp_2stage_final_0/m6_pmos_0/a_n52_n8116# 1.43738f
C668 sh_final_0/opamp_2stage_final_0/m6_pmos_0/a_n644_116# sh_final_0/opamp_2stage_final_0/m6_pmos_0/a_n356_116# 1.43738f
C669 pga_final_0/opamp_2stage_final_0/m3_pmos_0/a_52_24# pga_final_0/opamp_2stage_final_0/m3_pmos_0/a_556_24# 0.05997f
C670 sh_final_0/opamp_2stage_final_0/m1_nmos_0/a_556_n4208# sh_final_0/opamp_2stage_final_0/m1_nmos_0/a_556_24# 0.37451f
C671 sh_final_0/opamp_2stage_final_0/m6_pmos_0/a_n556_n8208# sh_final_0/opamp_2stage_final_0/m6_pmos_0/a_n356_n8116# 0.85436f
C672 pga_final_0/opamp_2stage_final_0/m2_7152_15850# pga_final_0/opamp_2stage_final_0/m6_pmos_0/a_n556_n8208# 0.08889f
C673 pga_final_0/opamp_2stage_final_0/m7_nmos_0/a_956_4348# pga_final_0/opamp_2stage_final_0/m7_nmos_0/a_452_4348# 0.39251f
C674 pga_final_0/opamp_2stage_final_0/m4_pmos_0/a_n452_n4440# pga_final_0/opamp_2stage_final_0/m4_pmos_0/a_n52_n4348# 0.29587f
C675 bias_final_0/bias_nmos_0/a_n452_24# bias_final_0/bias_nmos_0/a_52_24# 0.05997f
C676 sh_final_0/opamp_2stage_final_0/m4_pmos_0/a_52_n4440# sh_final_0/opamp_2stage_final_0/m4_pmos_0/a_452_n4348# 0.29587f
C677 pga_final_0/opamp_2stage_final_0/m3_pmos_0/a_n452_n4440# pga_final_0/opamp_2stage_final_0/m3_pmos_0/a_n452_n2208# 0.37451f
C678 pga_final_0/opamp_2stage_final_0/m2_nmos_0/a_556_n4208# pga_final_0/opamp_2stage_final_0/m2_nmos_0/a_452_n4116# 0.59234f
C679 sh_final_0/opamp_2stage_final_0/m1_nmos_0/a_452_n4116# sh_final_0/opamp_2stage_final_0/m1_nmos_0/a_n52_n4116# 0.39251f
C680 pga_final_0/opamp_2stage_final_0/m1_nmos_0/a_956_n8348# pga_final_0/opamp_2stage_final_0/m1_nmos_0/a_556_n8440# 0.59234f
C681 pga_final_0/opamp_2stage_final_0/m4_pmos_0/a_n556_n2116# pga_final_0/opamp_2stage_final_0/m4_pmos_0/w_n1220_n4604# 0.45674f
C682 pga_final_0/opamp_2stage_final_0/m5_nmos_0/a_556_24# pga_final_0/opamp_2stage_final_0/m5_nmos_0/a_556_n2208# 0.37451f
C683 pga_final_0/opamp_2stage_final_0/m1_nmos_0/a_n452_n8440# pga_final_0/opamp_2stage_final_0/m1_nmos_0/a_n556_n8348# 0.59234f
C684 sh_final_0/opamp_2stage_final_0/m4_pmos_0/a_n452_n4440# sh_final_0/opamp_2stage_final_0/m4_pmos_0/a_n956_n4440# 0.05997f
C685 sh_final_0/opamp_2stage_final_0/m3_pmos_0/a_556_n4440# sh_final_0/opamp_2stage_final_0/m3_pmos_0/a_556_n2208# 0.37451f
C686 sh_final_0/opamp_2stage_final_0/m3_pmos_0/a_452_n2116# sh_final_0/opamp_2stage_final_0/m3_pmos_0/a_n52_n2116# 0.19606f
C687 pga_final_0/opamp_2stage_final_0/m4_pmos_0/a_n556_2348# pga_final_0/opamp_2stage_final_0/m4_pmos_0/a_n52_2348# 0.19606f
C688 sh_final_0/opamp_2stage_final_0/m7_nmos_0/a_956_116# sh_final_0/opamp_2stage_final_0/m7_nmos_0/a_556_24# 0.59234f
C689 sh_final_0/opamp_2stage_final_0/m4_pmos_0/a_n52_n2116# sh_final_0/opamp_2stage_final_0/m4_pmos_0/w_n1220_n4604# 0.45673f
C690 pga_final_0/opamp_2stage_final_0/m3_pmos_0/w_n1220_n4604# pga_final_0/opamp_2stage_final_0/m3_pmos_0/a_n1044_n2116# 1.24508f
C691 pga_final_0/opamp_2stage_final_0/m5_nmos_0/a_n452_n2208# pga_final_0/opamp_2stage_final_0/m5_nmos_0/a_n52_n2116# 0.29587f
C692 pga_final_0/opamp_2stage_final_0/m3_pmos_0/a_452_n2116# pga_final_0/opamp_2stage_final_0/m3_pmos_0/a_956_n2116# 0.19606f
C693 pga_final_0/opamp_2stage_final_0/m6_pmos_0/a_356_n8208# pga_final_0/opamp_2stage_final_0/m6_pmos_0/a_356_24# 0.18596f
C694 pga_final_0/opamp_2stage_final_0/m1_nmos_0/a_n52_4348# pga_final_0/opamp_2stage_final_0/m1_nmos_0/a_n556_4348# 0.39251f
C695 pga_final_0/opamp_2stage_final_0/m2_nmos_0/a_52_24# pga_final_0/opamp_2stage_final_0/m2_nmos_0/a_n452_24# 0.05997f
C696 pga_final_0/opamp_2stage_final_0/m2_nmos_0/a_452_n4116# pga_final_0/opamp_2stage_final_0/m2_nmos_0/a_956_n4116# 0.39251f
C697 sh_final_0/opamp_2stage_final_0/m5_nmos_0/a_n52_2348# sh_final_0/opamp_2stage_final_0/m5_nmos_0/a_452_2348# 0.19606f
C698 sh_final_0/opamp_2stage_final_0/m7_nmos_0/a_52_n8440# sh_final_0/opamp_2stage_final_0/m7_nmos_0/a_52_n4208# 0.37451f
C699 sh_final_0/opamp_2stage_final_0/m2_nmos_0/a_52_n4208# sh_final_0/opamp_2stage_final_0/m2_nmos_0/a_n52_n4116# 0.59234f
C700 pga_final_0/opamp_2stage_final_0/m3_pmos_0/w_n1220_n4604# pga_final_0/opamp_2stage_final_0/m3_pmos_0/a_n956_n2208# 0.50114f
C701 pga_final_0/opamp_2stage_final_0/m2_nmos_0/a_n956_24# pga_final_0/opamp_2stage_final_0/m2_nmos_0/a_n556_116# 0.59234f
C702 sh_final_0/opamp_2stage_final_0/m1_nmos_0/a_52_n4208# sh_final_0/opamp_2stage_final_0/m1_nmos_0/a_52_24# 0.37451f
C703 sh_final_0/opamp_2stage_final_0/m2_nmos_0/a_n452_24# sh_final_0/opamp_2stage_final_0/m2_nmos_0/a_n452_4256# 0.37451f
C704 pga_final_0/opamp_2stage_final_0/m4_pmos_0/a_556_24# pga_final_0/opamp_2stage_final_0/m4_pmos_0/a_556_2256# 0.37451f
C705 sh_final_0/opamp_2stage_final_0/m5_nmos_0/a_n956_n2208# sh_final_0/opamp_2stage_final_0/m5_nmos_0/a_n956_24# 0.37451f
C706 sh_final_0/opamp_2stage_final_0/m1_n2152_32500# sh_final_0/opamp_2stage_final_0/m6_pmos_0/a_52_24# 0.25077f
C707 pga_final_0/opamp_2stage_final_0/m2_nmos_0/a_52_n8440# pga_final_0/opamp_2stage_final_0/m2_nmos_0/a_52_n4208# 0.37451f
C708 pga_final_0/opamp_2stage_final_0/m5_nmos_0/a_n556_116# pga_final_0/opamp_2stage_final_0/m5_nmos_0/a_n52_116# 0.19606f
C709 pga_final_0/opamp_2stage_final_0/m2_nmos_0/a_n52_n8348# pga_final_0/opamp_2stage_final_0/m2_nmos_0/a_452_n8348# 0.39251f
C710 sh_final_0/opamp_2stage_final_0/m7_nmos_0/a_n52_116# sh_final_0/opamp_2stage_final_0/m7_nmos_0/a_n556_116# 0.39251f
C711 sh_final_0/opamp_2stage_final_0/m4_pmos_0/a_n556_2348# sh_final_0/opamp_2stage_final_0/m4_pmos_0/a_n452_2256# 0.29587f
C712 sh_final_0/opamp_2stage_final_0/m4_pmos_0/a_452_2348# sh_final_0/opamp_2stage_final_0/m4_pmos_0/w_n1220_n4604# 0.47456f
C713 sh_final_0/opamp_2stage_final_0/m2_nmos_0/a_52_n8440# sh_final_0/opamp_2stage_final_0/m2_nmos_0/a_556_n8440# 0.05997f
C714 pga_final_0/opamp_2stage_final_0/m4_pmos_0/a_n52_116# pga_final_0/opamp_2stage_final_0/m4_pmos_0/a_n452_24# 0.29587f
C715 sh_final_0/opamp_2stage_final_0/m3_pmos_0/a_n956_n2208# sh_final_0/opamp_2stage_final_0/m3_pmos_0/w_n1220_n4604# 0.50114f
C716 pga_final_0/opamp_2stage_final_0/m3_pmos_0/w_n1220_n4604# pga_final_0/opamp_2stage_final_0/m3_pmos_0/a_n52_n2116# 0.45673f
C717 pga_final_0/opamp_2stage_final_0/m2_nmos_0/a_n452_24# pga_final_0/opamp_2stage_final_0/m2_nmos_0/a_n956_24# 0.05997f
C718 pga_final_0/opamp_2stage_final_0/m2_7152_15850# pga_final_0/opamp_2stage_final_0/m6_pmos_0/a_n644_n8116# 0.08049f
C719 sh_final_0/opamp_2stage_final_0/m5_nmos_0/a_52_2256# sh_final_0/opamp_2stage_final_0/m5_nmos_0/a_452_2348# 0.29587f
C720 pga_final_0/opamp_2stage_final_0/m5_nmos_0/a_452_116# pga_final_0/opamp_2stage_final_0/m5_nmos_0/a_52_24# 0.29587f
C721 pga_final_0/opamp_2stage_final_0/m3_pmos_0/a_452_116# pga_final_0/opamp_2stage_final_0/m3_pmos_0/a_52_24# 0.29587f
C722 sh_final_0/opamp_2stage_final_0/m1_nmos_0/a_556_n8440# sh_final_0/opamp_2stage_final_0/m1_nmos_0/a_452_n8348# 0.59234f
C723 sh_final_0/opamp_2stage_final_0/m5_nmos_0/a_n452_24# sh_final_0/opamp_2stage_final_0/m5_nmos_0/a_n556_116# 0.29587f
C724 sh_final_0/opamp_2stage_final_0/m7_nmos_0/a_n52_n4116# sh_final_0/opamp_2stage_final_0/m7_nmos_0/a_n452_n4208# 0.59234f
C725 sh_final_0/opamp_2stage_final_0/m3_pmos_0/a_n556_n4348# sh_final_0/opamp_2stage_final_0/m3_pmos_0/a_n452_n4440# 0.29587f
C726 sh_final_0/opamp_2stage_final_0/m2_nmos_0/a_52_n4208# sh_final_0/opamp_2stage_final_0/m2_nmos_0/a_52_n8440# 0.37451f
C727 pga_final_0/opamp_2stage_final_0/m3_pmos_0/a_52_2256# pga_final_0/opamp_2stage_final_0/m3_pmos_0/a_52_24# 0.37451f
C728 pga_final_0/opamp_2stage_final_0/m2_nmos_0/a_52_24# pga_final_0/opamp_2stage_final_0/m2_nmos_0/a_52_n4208# 0.37451f
C729 bias_final_0/bias_nmos_0/a_452_n1716# bias_final_0/bias_nmos_0/a_n52_n1716# 0.15677f
C730 pga_final_0/opamp_2stage_final_0/m5_nmos_0/a_452_2348# pga_final_0/opamp_2stage_final_0/m5_nmos_0/a_556_2256# 0.29587f
C731 pga_final_0/opamp_2stage_final_0/m5_nmos_0/a_n956_n4440# pga_final_0/opamp_2stage_final_0/m5_nmos_0/a_n556_n4348# 0.29587f
C732 pga_final_0/opamp_2stage_final_0/m6_pmos_0/a_356_n8208# pga_final_0/opamp_2stage_final_0/m6_pmos_0/a_52_n8208# 0.05997f
C733 pga_final_0/opamp_2stage_final_0/m6_pmos_0/a_n644_n8116# pga_final_0/opamp_2stage_final_0/m6_pmos_0/a_n556_n8208# 0.85436f
C734 sh_final_0/opamp_2stage_final_0/m1_nmos_0/a_n452_n4208# sh_final_0/opamp_2stage_final_0/m1_nmos_0/a_52_n4208# 0.05997f
C735 pga_final_0/opamp_2stage_final_0/m2_nmos_0/a_556_n8440# pga_final_0/opamp_2stage_final_0/m2_nmos_0/a_452_n8348# 0.59234f
C736 sh_final_0/opamp_2stage_final_0/m2_nmos_0/a_52_n8440# sh_final_0/opamp_2stage_final_0/m2_nmos_0/a_n452_n8440# 0.05997f
C737 pga_final_0/opamp_2stage_final_0/m5_nmos_0/a_452_n2116# pga_final_0/opamp_2stage_final_0/m5_nmos_0/a_n52_n2116# 0.19606f
C738 pga_final_0/opamp_2stage_final_0/m5_nmos_0/a_556_n4440# pga_final_0/opamp_2stage_final_0/m5_nmos_0/a_556_n2208# 0.37451f
C739 bias_final_0/bias_nmos_0/a_n52_n1716# bias_final_0/bias_nmos_0/a_n452_n1808# 0.23658f
C740 sh_final_0/opamp_2stage_final_0/m4_pmos_0/a_n556_116# sh_final_0/opamp_2stage_final_0/m4_pmos_0/a_n1044_116# 0.19606f
C741 sh_final_0/opamp_2stage_final_0/m4_pmos_0/a_452_116# sh_final_0/opamp_2stage_final_0/m4_pmos_0/a_52_24# 0.29587f
C742 sh_final_0/opamp_2stage_final_0/m3_pmos_0/w_n1220_n4604# sh_final_0/opamp_2stage_final_0/m3_pmos_0/a_n556_116# 0.45674f
C743 sh_final_0/opamp_2stage_final_0/m4_pmos_0/a_n452_n2208# sh_final_0/opamp_2stage_final_0/m4_pmos_0/a_52_n2208# 0.05997f
C744 pga_final_0/opamp_2stage_final_0/m2_nmos_0/a_n1044_n8348# pga_final_0/opamp_2stage_final_0/m2_nmos_0/a_n556_n8348# 0.39251f
C745 sh_final_0/opamp_2stage_final_0/m7_nmos_0/a_556_n4208# sh_final_0/opamp_2stage_final_0/m7_nmos_0/a_556_24# 0.37451f
C746 sh_final_0/opamp_2stage_final_0/m5_nmos_0/a_n452_n4440# sh_final_0/opamp_2stage_final_0/m5_nmos_0/a_n556_n4348# 0.29587f
C747 pga_final_0/opamp_2stage_final_0/m2_nmos_0/a_556_n4208# pga_final_0/opamp_2stage_final_0/m2_nmos_0/a_956_n4116# 0.59234f
C748 pga_final_0/opamp_2stage_final_0/m4_pmos_0/a_52_n4440# pga_final_0/opamp_2stage_final_0/m4_pmos_0/a_556_n4440# 0.05997f
C749 bias_final_0/bias_nmos_1/a_n52_116# bias_final_0/bias_nmos_1/a_52_24# 0.23658f
C750 sh_final_0/opamp_2stage_final_0/m1_nmos_0/a_n52_116# sh_final_0/opamp_2stage_final_0/m1_nmos_0/a_52_24# 0.59234f
C751 sh_final_0/opamp_2stage_final_0/m6_pmos_0/a_52_24# sh_final_0/opamp_2stage_final_0/m6_pmos_0/a_n252_24# 0.05997f
C752 pga_final_0/opamp_2stage_final_0/m4_pmos_0/a_52_2256# pga_final_0/opamp_2stage_final_0/m4_pmos_0/a_556_2256# 0.05997f
C753 pga_final_0/opamp_2stage_final_0/m3_pmos_0/a_n556_2348# pga_final_0/opamp_2stage_final_0/m3_pmos_0/a_n52_2348# 0.19606f
C754 sh_final_0/opamp_2stage_final_0/m2_7152_15850# sh_final_0/opamp_2stage_final_0/m6_pmos_0/a_n644_n8116# 0.08049f
C755 sh_final_0/opamp_2stage_final_0/m1_nmos_0/a_n556_n4116# sh_final_0/opamp_2stage_final_0/m1_nmos_0/a_n1044_n4116# 0.39251f
C756 sh_final_0/opamp_2stage_final_0/m6_pmos_0/a_356_8256# sh_final_0/opamp_2stage_final_0/m6_pmos_0/a_356_24# 0.18596f
C757 pga_final_0/opamp_2stage_final_0/m1_nmos_0/a_452_n8348# pga_final_0/opamp_2stage_final_0/m1_nmos_0/a_n52_n8348# 0.39251f
C758 pga_final_0/opamp_2stage_final_0/m4_pmos_0/a_n556_n2116# pga_final_0/opamp_2stage_final_0/m4_pmos_0/a_n52_n2116# 0.19606f
C759 sh_final_0/opamp_2stage_final_0/m1_nmos_0/a_452_4348# sh_final_0/opamp_2stage_final_0/m1_nmos_0/a_556_4256# 0.59234f
C760 pga_final_0/opamp_2stage_final_0/m3_pmos_0/w_n1220_n4604# pga_final_0/opamp_2stage_final_0/m3_pmos_0/a_n52_n4348# 0.47455f
C761 sh_final_0/opamp_2stage_final_0/m4_pmos_0/a_956_n2116# sh_final_0/opamp_2stage_final_0/m4_pmos_0/a_556_n2208# 0.29587f
C762 sh_final_0/opamp_2stage_final_0/m3_pmos_0/a_n556_2348# sh_final_0/opamp_2stage_final_0/m3_pmos_0/a_n1044_2348# 0.19606f
C763 sh_final_0/opamp_2stage_final_0/m2_nmos_0/a_n556_n8348# sh_final_0/opamp_2stage_final_0/m2_nmos_0/a_n452_n8440# 0.59234f
C764 sh_final_0/opamp_2stage_final_0/m7_nmos_0/a_n52_116# sh_final_0/opamp_2stage_final_0/m7_nmos_0/a_52_24# 0.59234f
C765 sh_final_0/opamp_2stage_final_0/m3_pmos_0/a_n956_n4440# sh_final_0/opamp_2stage_final_0/m3_pmos_0/a_n556_n4348# 0.29587f
C766 pga_final_0/opamp_2stage_final_0/m5_nmos_0/a_n452_n2208# pga_final_0/opamp_2stage_final_0/m5_nmos_0/a_52_n2208# 0.05997f
C767 sh_final_0/opamp_2stage_final_0/m3_pmos_0/a_956_n4348# sh_final_0/opamp_2stage_final_0/m3_pmos_0/a_452_n4348# 0.19606f
C768 sh_final_0/opamp_2stage_final_0/m2_7152_15850# sh_final_0/opamp_2stage_final_0/m6_pmos_0/a_n252_n8208# 0.08782f
C769 sh_final_0/opamp_2stage_final_0/m4_pmos_0/a_n52_n2116# sh_final_0/opamp_2stage_final_0/m4_pmos_0/a_n556_n2116# 0.19606f
C770 pga_final_0/opamp_2stage_final_0/m7_nmos_0/a_n52_n8348# pga_final_0/opamp_2stage_final_0/m7_nmos_0/a_n556_n8348# 0.39251f
C771 sh_final_0/opamp_2stage_final_0/m3_pmos_0/a_956_2348# sh_final_0/opamp_2stage_final_0/m3_pmos_0/a_556_2256# 0.29587f
C772 pga_final_0/opamp_2stage_final_0/m3_pmos_0/a_556_n4440# pga_final_0/opamp_2stage_final_0/m3_pmos_0/a_452_n4348# 0.29587f
C773 pga_final_0/opamp_2stage_final_0/m1_nmos_0/a_n452_4256# pga_final_0/opamp_2stage_final_0/m1_nmos_0/a_n452_24# 0.37451f
C774 pga_final_0/opamp_2stage_final_0/m4_pmos_0/a_52_24# pga_final_0/opamp_2stage_final_0/m4_pmos_0/a_556_24# 0.05997f
C775 sh_final_0/opamp_2stage_final_0/m3_pmos_0/w_n1220_n4604# sh_final_0/opamp_2stage_final_0/m3_pmos_0/a_n556_n2116# 0.45674f
C776 pga_final_0/opamp_2stage_final_0/m3_pmos_0/a_556_n4440# pga_final_0/opamp_2stage_final_0/m3_pmos_0/a_52_n4440# 0.05997f
C777 pga_final_0/opamp_2stage_final_0/m3_pmos_0/w_n1220_n4604# pga_final_0/opamp_2stage_final_0/m3_pmos_0/a_n1044_n4348# 1.26104f
C778 sh_final_0/opamp_2stage_final_0/m7_nmos_0/a_556_24# sh_final_0/opamp_2stage_final_0/m7_nmos_0/a_556_4256# 0.37451f
C779 pga_final_0/opamp_2stage_final_0/m2_nmos_0/a_452_4348# pga_final_0/opamp_2stage_final_0/m2_nmos_0/a_956_4348# 0.39251f
C780 sh_final_0/opamp_2stage_final_0/m4_pmos_0/a_956_n4348# sh_final_0/opamp_2stage_final_0/m4_pmos_0/w_n1220_n4604# 1.26104f
C781 sh_final_0/opamp_2stage_final_0/m3_pmos_0/a_452_n2116# sh_final_0/opamp_2stage_final_0/m3_pmos_0/w_n1220_n4604# 0.45674f
C782 pga_final_0/opamp_2stage_final_0/m3_pmos_0/a_556_2256# pga_final_0/opamp_2stage_final_0/m3_pmos_0/a_956_2348# 0.29587f
C783 pga_final_0/opamp_2stage_final_0/m6_pmos_0/a_252_116# pga_final_0/opamp_2stage_final_0/m6_pmos_0/a_356_24# 0.85436f
C784 sh_final_0/opamp_2stage_final_0/m3_pmos_0/a_452_2348# sh_final_0/opamp_2stage_final_0/m3_pmos_0/a_n52_2348# 0.19606f
C785 sh_final_0/opamp_2stage_final_0/m3_pmos_0/a_52_2256# sh_final_0/opamp_2stage_final_0/m3_pmos_0/a_52_24# 0.37451f
C786 sh_final_0/opamp_2stage_final_0/m5_nmos_0/a_556_n2208# sh_final_0/opamp_2stage_final_0/m5_nmos_0/a_556_24# 0.37451f
C787 pga_final_0/opamp_2stage_final_0/m3_pmos_0/a_452_2348# pga_final_0/opamp_2stage_final_0/m3_pmos_0/a_556_2256# 0.29587f
C788 sh_final_0/opamp_2stage_final_0/m7_nmos_0/a_n452_n4208# sh_final_0/opamp_2stage_final_0/m7_nmos_0/a_n452_n8440# 0.37451f
C789 pga_final_0/opamp_2stage_final_0/m3_pmos_0/a_n556_2348# pga_final_0/opamp_2stage_final_0/m3_pmos_0/a_n1044_2348# 0.19606f
C790 pga_final_0/opamp_2stage_final_0/m4_pmos_0/w_n1220_n4604# pga_final_0/opamp_2stage_final_0/m4_pmos_0/a_n452_2256# 0.71938f
C791 sh_final_0/opamp_2stage_final_0/m2_nmos_0/a_n52_4348# sh_final_0/opamp_2stage_final_0/m2_nmos_0/a_52_4256# 0.59234f
C792 sh_final_0/opamp_2stage_final_0/m1_n2152_32500# sh_final_0/opamp_2stage_final_0/m6_pmos_0/a_n644_n8116# 4.72133f
C793 sh_final_0/opamp_2stage_final_0/m3_pmos_0/a_556_n2208# sh_final_0/opamp_2stage_final_0/m3_pmos_0/a_556_24# 0.37451f
C794 pga_final_0/opamp_2stage_final_0/m5_nmos_0/a_52_n2208# pga_final_0/opamp_2stage_final_0/m5_nmos_0/a_452_n2116# 0.29587f
C795 sh_final_0/opamp_2stage_final_0/m3_pmos_0/w_n1220_n4604# sh_final_0/opamp_2stage_final_0/m3_pmos_0/a_956_n4348# 1.26104f
C796 sh_final_0/opamp_2stage_final_0/m3_pmos_0/a_n1044_n2116# sh_final_0/opamp_2stage_final_0/m3_pmos_0/w_n1220_n4604# 1.24508f
C797 pga_final_0/opamp_2stage_final_0/m4_pmos_0/w_n1220_n4604# pga_final_0/opamp_2stage_final_0/m4_pmos_0/a_452_2348# 0.47456f
C798 pga_final_0/opamp_2stage_final_0/m5_nmos_0/a_52_n4440# pga_final_0/opamp_2stage_final_0/m5_nmos_0/a_556_n4440# 0.05997f
C799 pga_final_0/opamp_2stage_final_0/m6_pmos_0/a_n252_n16440# pga_final_0/opamp_2stage_final_0/m6_pmos_0/a_n556_n16440# 0.05997f
C800 sh_final_0/opamp_2stage_final_0/m7_nmos_0/a_n52_n8348# sh_final_0/opamp_2stage_final_0/m7_nmos_0/a_452_n8348# 0.39251f
C801 sh_final_0/opamp_2stage_final_0/m3_pmos_0/a_n52_n4348# sh_final_0/opamp_2stage_final_0/m3_pmos_0/a_n452_n4440# 0.29587f
C802 sh_final_0/opamp_2stage_final_0/m7_nmos_0/a_n52_n4116# sh_final_0/opamp_2stage_final_0/m7_nmos_0/a_52_n4208# 0.59234f
C803 pga_final_0/opamp_2stage_final_0/m4_pmos_0/a_52_24# pga_final_0/opamp_2stage_final_0/m4_pmos_0/a_52_2256# 0.37451f
C804 sh_final_0/opamp_2stage_final_0/m1_nmos_0/a_n52_4348# sh_final_0/opamp_2stage_final_0/m1_nmos_0/a_452_4348# 0.39251f
C805 sh_final_0/opamp_2stage_final_0/m1_n2152_32500# sh_final_0/opamp_2stage_final_0/m6_pmos_0/a_n252_n8208# 0.25049f
C806 pga_final_0/opamp_2stage_final_0/m2_nmos_0/a_n956_n4208# pga_final_0/opamp_2stage_final_0/m2_nmos_0/a_n556_n4116# 0.59234f
C807 sh_final_0/opamp_2stage_final_0/m3_pmos_0/a_n556_2348# sh_final_0/opamp_2stage_final_0/m3_pmos_0/w_n1220_n4604# 0.47456f
C808 pga_final_0/opamp_2stage_final_0/m5_nmos_0/a_n452_n2208# pga_final_0/opamp_2stage_final_0/m5_nmos_0/a_n452_n4440# 0.37451f
C809 sh_final_0/opamp_2stage_final_0/m1_nmos_0/a_n52_n4116# sh_final_0/opamp_2stage_final_0/m1_nmos_0/a_n556_n4116# 0.39251f
C810 pga_final_0/opamp_2stage_final_0/m7_nmos_0/a_n452_4256# pga_final_0/opamp_2stage_final_0/m7_nmos_0/a_n452_24# 0.37451f
C811 pga_final_0/opamp_2stage_final_0/m2_nmos_0/a_n452_n4208# pga_final_0/opamp_2stage_final_0/m2_nmos_0/a_n556_n4116# 0.59234f
C812 sh_final_0/opamp_2stage_final_0/m1_nmos_0/a_n956_n8440# sh_final_0/opamp_2stage_final_0/m1_nmos_0/a_n956_n4208# 0.37451f
C813 sh_final_0/opamp_2stage_final_0/m5_nmos_0/a_n452_n4440# sh_final_0/opamp_2stage_final_0/m5_nmos_0/a_n956_n4440# 0.05997f
C814 pga_final_0/opamp_2stage_final_0/m4_pmos_0/a_n556_2348# pga_final_0/opamp_2stage_final_0/m4_pmos_0/a_n956_2256# 0.29587f
C815 pga_final_0/opamp_2stage_final_0/m7_nmos_0/a_556_n8440# pga_final_0/opamp_2stage_final_0/m7_nmos_0/a_956_n8348# 0.59234f
C816 sh_final_0/opamp_2stage_final_0/m6_pmos_0/a_n252_n16440# sh_final_0/opamp_2stage_final_0/m6_pmos_0/a_n252_n8208# 0.18596f
C817 pga_final_0/opamp_2stage_final_0/m4_pmos_0/a_n556_n2116# pga_final_0/opamp_2stage_final_0/m4_pmos_0/a_n1044_n2116# 0.19606f
C818 pga_final_0/opamp_2stage_final_0/m4_pmos_0/a_452_116# pga_final_0/opamp_2stage_final_0/m4_pmos_0/a_556_24# 0.29587f
C819 sh_final_0/opamp_2stage_final_0/m1_n2152_32500# sh_final_0/opamp_2stage_final_0/m6_pmos_0/a_n556_8256# 2.60766f
C820 sh_final_0/opamp_2stage_final_0/m2_nmos_0/a_n452_n8440# sh_final_0/opamp_2stage_final_0/m2_nmos_0/a_n956_n8440# 0.05997f
C821 pga_final_0/opamp_2stage_final_0/m4_pmos_0/a_556_n4440# pga_final_0/opamp_2stage_final_0/m4_pmos_0/a_956_n4348# 0.29587f
C822 pga_final_0/opamp_2stage_final_0/m5_nmos_0/a_n956_24# pga_final_0/opamp_2stage_final_0/m5_nmos_0/a_n956_n2208# 0.37451f
C823 sh_final_0/opamp_2stage_final_0/m7_nmos_0/a_n556_n4116# sh_final_0/opamp_2stage_final_0/m7_nmos_0/a_n1044_n4116# 0.39251f
C824 sh_final_0/opamp_2stage_final_0/m4_pmos_0/a_n556_2348# sh_final_0/opamp_2stage_final_0/m4_pmos_0/a_n1044_2348# 0.19606f
C825 sh_final_0/opamp_2stage_final_0/m4_pmos_0/a_n452_24# sh_final_0/opamp_2stage_final_0/m4_pmos_0/w_n1220_n4604# 0.45835f
C826 sh_final_0/opamp_2stage_final_0/m4_pmos_0/a_n956_24# sh_final_0/opamp_2stage_final_0/m4_pmos_0/a_n956_2256# 0.37451f
C827 sh_final_0/opamp_2stage_final_0/m4_pmos_0/a_452_2348# sh_final_0/opamp_2stage_final_0/m4_pmos_0/a_52_2256# 0.29587f
C828 sh_final_0/opamp_2stage_final_0/m3_pmos_0/a_52_2256# sh_final_0/opamp_2stage_final_0/m3_pmos_0/w_n1220_n4604# 0.71938f
C829 sh_final_0/opamp_2stage_final_0/m7_nmos_0/a_556_n4208# sh_final_0/opamp_2stage_final_0/m7_nmos_0/a_556_n8440# 0.37451f
C830 pga_final_0/opamp_2stage_final_0/m1_nmos_0/a_n52_116# pga_final_0/opamp_2stage_final_0/m1_nmos_0/a_52_24# 0.59234f
C831 pga_final_0/opamp_2stage_final_0/m1_nmos_0/a_52_24# pga_final_0/opamp_2stage_final_0/m1_nmos_0/a_52_4256# 0.37451f
C832 pga_final_0/opamp_2stage_final_0/m2_nmos_0/a_n452_24# pga_final_0/opamp_2stage_final_0/m2_nmos_0/a_n452_4256# 0.37451f
C833 sh_final_0/opamp_2stage_final_0/m5_nmos_0/a_n556_2348# sh_final_0/opamp_2stage_final_0/m5_nmos_0/a_n956_2256# 0.29587f
C834 sh_final_0/opamp_2stage_final_0/m5_nmos_0/a_956_n2116# sh_final_0/opamp_2stage_final_0/m5_nmos_0/a_556_n2208# 0.29587f
C835 pga_final_0/opamp_2stage_final_0/m4_pmos_0/a_n452_2256# pga_final_0/opamp_2stage_final_0/m4_pmos_0/a_n52_2348# 0.29587f
C836 pga_final_0/opamp_2stage_final_0/m2_nmos_0/a_n556_4348# pga_final_0/opamp_2stage_final_0/m2_nmos_0/a_n452_4256# 0.59234f
C837 sh_final_0/opamp_2stage_final_0/m5_nmos_0/a_n1044_2348# sh_final_0/opamp_2stage_final_0/m5_nmos_0/a_n956_2256# 0.29587f
C838 sh_final_0/opamp_2stage_final_0/m1_n2152_32500# sh_final_0/opamp_2stage_final_0/m6_pmos_0/a_n644_116# 4.72381f
C839 sh_final_0/opamp_2stage_final_0/m6_pmos_0/a_n252_8256# sh_final_0/opamp_2stage_final_0/m6_pmos_0/a_52_8256# 0.05997f
C840 pga_final_0/opamp_2stage_final_0/m4_pmos_0/a_556_n2208# pga_final_0/opamp_2stage_final_0/m4_pmos_0/a_452_n2116# 0.29587f
C841 sh_final_0/opamp_2stage_final_0/m7_nmos_0/a_n556_n8348# sh_final_0/opamp_2stage_final_0/m7_nmos_0/a_n452_n8440# 0.59234f
C842 sh_final_0/opamp_2stage_final_0/m4_pmos_0/a_n956_n2208# sh_final_0/opamp_2stage_final_0/m4_pmos_0/w_n1220_n4604# 0.50114f
C843 sh_final_0/opamp_2stage_final_0/m6_pmos_0/a_n252_24# sh_final_0/opamp_2stage_final_0/m6_pmos_0/a_n252_n8208# 0.18596f
C844 sh_final_0/opamp_2stage_final_0/m3_pmos_0/a_n956_24# sh_final_0/opamp_2stage_final_0/m3_pmos_0/a_n956_n2208# 0.37451f
C845 bias_final_0/bias_nmos_1/a_52_24# bias_final_0/bias_nmos_1/a_n452_24# 0.05997f
C846 sh_final_0/opamp_2stage_final_0/m2_nmos_0/a_n956_n4208# sh_final_0/opamp_2stage_final_0/m2_nmos_0/a_n556_n4116# 0.59234f
C847 pga_final_0/opamp_2stage_final_0/m4_pmos_0/w_n1220_n4604# pga_final_0/opamp_2stage_final_0/m4_pmos_0/a_n1044_116# 1.24508f
C848 pga_final_0/opamp_2stage_final_0/m4_pmos_0/a_452_2348# pga_final_0/opamp_2stage_final_0/m4_pmos_0/a_n52_2348# 0.19606f
C849 pga_final_0/opamp_2stage_final_0/m6_pmos_0/a_n52_n8116# pga_final_0/opamp_2stage_final_0/m6_pmos_0/a_n252_n8208# 0.85436f
C850 pga_final_0/opamp_2stage_final_0/m4_pmos_0/a_n1044_116# pga_final_0/opamp_2stage_final_0/m4_pmos_0/a_n556_116# 0.19606f
C851 sh_final_0/opamp_2stage_final_0/m4_pmos_0/a_556_n2208# sh_final_0/opamp_2stage_final_0/m4_pmos_0/a_52_n2208# 0.05997f
C852 bias_final_0/bias_nmos_0/a_n52_116# bias_final_0/bias_nmos_0/a_n540_116# 0.15677f
C853 pga_final_0/opamp_2stage_final_0/m1_nmos_0/a_452_4348# pga_final_0/opamp_2stage_final_0/m1_nmos_0/a_956_4348# 0.39251f
C854 pga_final_0/opamp_2stage_final_0/m4_pmos_0/a_452_116# pga_final_0/opamp_2stage_final_0/m4_pmos_0/a_52_24# 0.29587f
C855 sh_final_0/opamp_2stage_final_0/m1_nmos_0/a_956_n4116# sh_final_0/opamp_2stage_final_0/m1_nmos_0/a_556_n4208# 0.59234f
C856 sh_final_0/opamp_2stage_final_0/m6_pmos_0/a_356_24# sh_final_0/opamp_2stage_final_0/m6_pmos_0/a_252_116# 0.85436f
C857 pga_final_0/opamp_2stage_final_0/m7_nmos_0/a_n956_n4208# pga_final_0/opamp_2stage_final_0/m7_nmos_0/a_n956_24# 0.37451f
C858 pga_final_0/opamp_2stage_final_0/m1_nmos_0/a_52_24# pga_final_0/opamp_2stage_final_0/m1_nmos_0/a_556_24# 0.05997f
C859 pga_final_0/opamp_2stage_final_0/m4_pmos_0/a_452_n4348# pga_final_0/opamp_2stage_final_0/m4_pmos_0/w_n1220_n4604# 0.47456f
C860 sh_final_0/opamp_2stage_final_0/m1_nmos_0/a_n52_116# sh_final_0/opamp_2stage_final_0/m1_nmos_0/a_452_116# 0.39251f
C861 pga_final_0/opamp_2stage_final_0/m5_nmos_0/a_n52_2348# pga_final_0/opamp_2stage_final_0/m5_nmos_0/a_n556_2348# 0.19606f
C862 sh_final_0/opamp_2stage_final_0/m4_pmos_0/a_n556_n2116# sh_final_0/opamp_2stage_final_0/m4_pmos_0/w_n1220_n4604# 0.45674f
C863 sh_final_0/opamp_2stage_final_0/m3_pmos_0/a_n956_24# sh_final_0/opamp_2stage_final_0/m3_pmos_0/a_n556_116# 0.29587f
C864 sh_final_0/opamp_2stage_final_0/m4_pmos_0/a_52_24# sh_final_0/opamp_2stage_final_0/m4_pmos_0/w_n1220_n4604# 0.45835f
C865 pga_final_0/opamp_2stage_final_0/m3_pmos_0/a_n452_24# pga_final_0/opamp_2stage_final_0/m3_pmos_0/a_n452_n2208# 0.37451f
C866 sh_final_0/opamp_2stage_final_0/m5_nmos_0/a_n1044_n4348# sh_final_0/opamp_2stage_final_0/m5_nmos_0/a_n556_n4348# 0.19606f
C867 sh_final_0/opamp_2stage_final_0/m1_nmos_0/a_52_24# sh_final_0/opamp_2stage_final_0/m1_nmos_0/a_52_4256# 0.37451f
C868 sh_final_0/opamp_2stage_final_0/m4_pmos_0/a_556_n4440# sh_final_0/opamp_2stage_final_0/m4_pmos_0/a_556_n2208# 0.37451f
C869 sh_final_0/opamp_2stage_final_0/m7_nmos_0/a_n956_n8440# sh_final_0/opamp_2stage_final_0/m7_nmos_0/a_n1044_n8348# 0.59234f
C870 pga_final_0/opamp_2stage_final_0/m4_pmos_0/a_n556_n4348# pga_final_0/opamp_2stage_final_0/m4_pmos_0/a_n452_n4440# 0.29587f
C871 sh_final_0/opamp_2stage_final_0/m6_pmos_0/a_n556_n8208# sh_final_0/opamp_2stage_final_0/m6_pmos_0/a_n556_24# 0.18596f
C872 pga_final_0/opamp_2stage_final_0/m1_nmos_0/a_n556_n4116# pga_final_0/opamp_2stage_final_0/m1_nmos_0/a_n956_n4208# 0.59234f
C873 sh_final_0/opamp_2stage_final_0/m5_nmos_0/a_n52_2348# sh_final_0/opamp_2stage_final_0/m5_nmos_0/a_n556_2348# 0.19606f
C874 sh_final_0/opamp_2stage_final_0/m2_nmos_0/a_n556_116# sh_final_0/opamp_2stage_final_0/m2_nmos_0/a_n1044_116# 0.39251f
C875 pga_final_0/opamp_2stage_final_0/m4_pmos_0/w_n1220_n4604# pga_final_0/opamp_2stage_final_0/m4_pmos_0/a_556_n2208# 0.50114f
C876 pga_final_0/opamp_2stage_final_0/m1_nmos_0/a_52_24# pga_final_0/opamp_2stage_final_0/m1_nmos_0/a_52_n4208# 0.37451f
C877 sh_final_0/opamp_2stage_final_0/m2_nmos_0/a_452_n8348# sh_final_0/opamp_2stage_final_0/m2_nmos_0/a_n52_n8348# 0.39251f
C878 sh_final_0/opamp_2stage_final_0/m3_pmos_0/w_n1220_n4604# sh_final_0/opamp_2stage_final_0/m3_pmos_0/a_n452_2256# 0.71938f
C879 sh_final_0/opamp_2stage_final_0/m5_nmos_0/a_452_n4348# sh_final_0/opamp_2stage_final_0/m5_nmos_0/a_52_n4440# 0.29587f
C880 sh_final_0/opamp_2stage_final_0/m2_nmos_0/a_n956_n4208# sh_final_0/opamp_2stage_final_0/m2_nmos_0/a_n452_n4208# 0.05997f
C881 pga_final_0/opamp_2stage_final_0/m6_pmos_0/a_n52_n8116# pga_final_0/opamp_2stage_final_0/m6_pmos_0/a_n356_n8116# 1.43738f
C882 pga_final_0/opamp_2stage_final_0/m3_pmos_0/a_52_2256# pga_final_0/opamp_2stage_final_0/m3_pmos_0/a_452_2348# 0.29587f
C883 sh_final_0/opamp_2stage_final_0/m1_nmos_0/a_n452_n8440# sh_final_0/opamp_2stage_final_0/m1_nmos_0/a_n556_n8348# 0.59234f
C884 sh_final_0/opamp_2stage_final_0/m2_nmos_0/a_452_116# sh_final_0/opamp_2stage_final_0/m2_nmos_0/a_956_116# 0.39251f
C885 pga_final_0/opamp_2stage_final_0/m1_nmos_0/a_n956_24# pga_final_0/opamp_2stage_final_0/m1_nmos_0/a_n1044_116# 0.59234f
C886 pga_final_0/opamp_2stage_final_0/m5_nmos_0/a_556_24# pga_final_0/opamp_2stage_final_0/m5_nmos_0/a_956_116# 0.29587f
C887 pga_final_0/opamp_2stage_final_0/m1_nmos_0/a_556_24# pga_final_0/opamp_2stage_final_0/m1_nmos_0/a_956_116# 0.59234f
C888 pga_final_0/opamp_2stage_final_0/m1_nmos_0/a_52_24# pga_final_0/opamp_2stage_final_0/m1_nmos_0/a_452_116# 0.59234f
C889 pga_final_0/opamp_2stage_final_0/m6_pmos_0/a_252_116# pga_final_0/opamp_2stage_final_0/m6_pmos_0/a_n52_116# 1.43738f
C890 sh_final_0/opamp_2stage_final_0/m7_nmos_0/a_52_n8440# sh_final_0/opamp_2stage_final_0/m7_nmos_0/a_556_n8440# 0.05997f
C891 pga_final_0/opamp_2stage_final_0/m3_pmos_0/a_956_116# pga_final_0/opamp_2stage_final_0/m3_pmos_0/a_556_24# 0.29587f
C892 sh_final_0/opamp_2stage_final_0/m4_pmos_0/a_52_24# sh_final_0/opamp_2stage_final_0/m4_pmos_0/a_n452_24# 0.05997f
C893 sh_final_0/opamp_2stage_final_0/m3_pmos_0/a_n956_n4440# sh_final_0/opamp_2stage_final_0/m3_pmos_0/a_n1044_n4348# 0.29587f
C894 pga_final_0/opamp_2stage_final_0/m5_nmos_0/a_n956_24# pga_final_0/opamp_2stage_final_0/m5_nmos_0/a_n956_2256# 0.37451f
C895 pga_final_0/opamp_2stage_final_0/m2_nmos_0/a_n956_n4208# pga_final_0/opamp_2stage_final_0/m2_nmos_0/a_n1044_n4116# 0.59234f
C896 sh_final_0/opamp_2stage_final_0/m1_nmos_0/a_556_24# sh_final_0/opamp_2stage_final_0/m1_nmos_0/a_52_24# 0.05997f
C897 sh_final_0/opamp_2stage_final_0/m1_nmos_0/a_n556_116# sh_final_0/opamp_2stage_final_0/m1_nmos_0/a_n452_24# 0.59234f
C898 sh_final_0/opamp_2stage_final_0/m5_nmos_0/a_956_2348# sh_final_0/opamp_2stage_final_0/m5_nmos_0/a_452_2348# 0.19606f
C899 sh_final_0/opamp_2stage_final_0/m5_nmos_0/a_n52_n2116# sh_final_0/opamp_2stage_final_0/m5_nmos_0/a_n556_n2116# 0.19606f
C900 pga_final_0/opamp_2stage_final_0/m2_nmos_0/a_n452_n4208# pga_final_0/opamp_2stage_final_0/m2_nmos_0/a_n52_n4116# 0.59234f
C901 sh_final_0/opamp_2stage_final_0/m2_nmos_0/a_n52_4348# sh_final_0/opamp_2stage_final_0/m2_nmos_0/a_n556_4348# 0.39251f
C902 sh_final_0/opamp_2stage_final_0/m2_nmos_0/a_556_24# sh_final_0/opamp_2stage_final_0/m2_nmos_0/a_956_116# 0.59234f
C903 pga_final_0/opamp_2stage_final_0/m7_nmos_0/a_n956_n4208# pga_final_0/opamp_2stage_final_0/m7_nmos_0/a_n956_n8440# 0.37451f
C904 pga_final_0/opamp_2stage_final_0/m2_nmos_0/a_52_n8440# pga_final_0/opamp_2stage_final_0/m2_nmos_0/a_452_n8348# 0.59234f
C905 pga_final_0/opamp_2stage_final_0/m1_nmos_0/a_n556_116# pga_final_0/opamp_2stage_final_0/m1_nmos_0/a_n452_24# 0.59234f
C906 pga_final_0/opamp_2stage_final_0/m3_pmos_0/a_n52_n4348# pga_final_0/opamp_2stage_final_0/m3_pmos_0/a_452_n4348# 0.19606f
C907 pga_final_0/opamp_2stage_final_0/m7_nmos_0/a_n452_n4208# pga_final_0/opamp_2stage_final_0/m7_nmos_0/a_52_n4208# 0.05997f
C908 pga_final_0/opamp_2stage_final_0/m3_pmos_0/a_n52_n4348# pga_final_0/opamp_2stage_final_0/m3_pmos_0/a_52_n4440# 0.29587f
C909 bias_final_0/bias_nmos_1/a_52_24# bias_final_0/bias_nmos_1/a_452_116# 0.23658f
C910 sh_final_0/opamp_2stage_final_0/m4_pmos_0/a_n452_2256# sh_final_0/opamp_2stage_final_0/m4_pmos_0/a_n956_2256# 0.05997f
C911 sh_final_0/opamp_2stage_final_0/m4_pmos_0/a_n556_n2116# sh_final_0/opamp_2stage_final_0/m4_pmos_0/a_n956_n2208# 0.29587f
C912 sh_final_0/opamp_2stage_final_0/m4_pmos_0/a_52_2256# sh_final_0/opamp_2stage_final_0/m4_pmos_0/w_n1220_n4604# 0.71938f
C913 sh_final_0/opamp_2stage_final_0/m5_nmos_0/a_n556_116# sh_final_0/opamp_2stage_final_0/m5_nmos_0/a_n956_24# 0.29587f
C914 pga_final_0/opamp_2stage_final_0/m2_nmos_0/a_556_4256# pga_final_0/opamp_2stage_final_0/m2_nmos_0/a_52_4256# 0.05997f
C915 sh_final_0/sw_nmos_1/a_n100_n492# sh_final_0/sw_nmos_1/a_n188_n400# 0.08505f
C916 sh_final_0/opamp_2stage_final_0/m5_nmos_0/a_n52_n4348# sh_final_0/opamp_2stage_final_0/m5_nmos_0/a_452_n4348# 0.19606f
C917 pga_final_0/opamp_2stage_final_0/m2_nmos_0/a_n556_n8348# pga_final_0/opamp_2stage_final_0/m2_nmos_0/a_n452_n8440# 0.59234f
C918 pga_final_0/opamp_2stage_final_0/m3_pmos_0/a_n52_2348# pga_final_0/opamp_2stage_final_0/m3_pmos_0/a_n452_2256# 0.29587f
C919 pga_final_0/opamp_2stage_final_0/m2_nmos_0/a_956_n8348# pga_final_0/opamp_2stage_final_0/m2_nmos_0/a_452_n8348# 0.39251f
C920 bias_final_0/bias_nmos_1/a_n52_116# bias_final_0/bias_nmos_1/a_n452_24# 0.23658f
C921 sh_final_0/opamp_2stage_final_0/m7_nmos_0/a_n556_n8348# sh_final_0/opamp_2stage_final_0/m7_nmos_0/a_n52_n8348# 0.39251f
C922 pga_final_0/opamp_2stage_final_0/m5_nmos_0/a_52_n4440# pga_final_0/opamp_2stage_final_0/m5_nmos_0/a_452_n4348# 0.29587f
C923 sh_final_0/opamp_2stage_final_0/m3_pmos_0/a_52_2256# sh_final_0/opamp_2stage_final_0/m3_pmos_0/a_556_2256# 0.05997f
C924 sh_final_0/opamp_2stage_final_0/m1_nmos_0/a_452_n4116# sh_final_0/opamp_2stage_final_0/m1_nmos_0/a_556_n4208# 0.59234f
C925 pga_final_0/opamp_2stage_final_0/m1_nmos_0/a_956_116# pga_final_0/opamp_2stage_final_0/m1_nmos_0/a_452_116# 0.39251f
C926 bias_final_0/bias_nmos_1/a_n52_116# bias_final_0/bias_nmos_1/a_n540_116# 0.15677f
C927 sh_final_0/opamp_2stage_final_0/m7_nmos_0/a_n956_n4208# sh_final_0/opamp_2stage_final_0/m7_nmos_0/a_n956_n8440# 0.37451f
C928 sh_final_0/opamp_2stage_final_0/m3_pmos_0/a_556_n4440# sh_final_0/opamp_2stage_final_0/m3_pmos_0/a_452_n4348# 0.29587f
C929 sh_final_0/opamp_2stage_final_0/m7_nmos_0/a_n452_4256# sh_final_0/opamp_2stage_final_0/m7_nmos_0/a_n452_24# 0.37451f
C930 pga_final_0/opamp_2stage_final_0/m5_nmos_0/a_n452_24# pga_final_0/opamp_2stage_final_0/m5_nmos_0/a_n556_116# 0.29587f
C931 pga_final_0/opamp_2stage_final_0/m3_pmos_0/a_n956_2256# pga_final_0/opamp_2stage_final_0/m3_pmos_0/w_n1220_n4604# 0.76217f
C932 pga_final_0/opamp_2stage_final_0/m7_nmos_0/a_n956_24# pga_final_0/opamp_2stage_final_0/m7_nmos_0/a_n452_24# 0.05997f
C933 pga_final_0/opamp_2stage_final_0/m6_pmos_0/a_52_n8208# pga_final_0/opamp_2stage_final_0/m6_pmos_0/a_n252_n8208# 0.05997f
C934 pga_final_0/opamp_2stage_final_0/m7_nmos_0/a_452_116# pga_final_0/opamp_2stage_final_0/m7_nmos_0/a_n52_116# 0.39251f
C935 pga_final_0/opamp_2stage_final_0/m3_pmos_0/a_n556_n2116# pga_final_0/opamp_2stage_final_0/m3_pmos_0/a_n452_n2208# 0.29587f
C936 sh_final_0/opamp_2stage_final_0/m1_nmos_0/a_n1044_n4116# sh_final_0/opamp_2stage_final_0/m1_nmos_0/a_n956_n4208# 0.59234f
C937 sh_final_0/opamp_2stage_final_0/m6_pmos_0/a_356_n8208# sh_final_0/opamp_2stage_final_0/m6_pmos_0/a_52_n8208# 0.05997f
C938 pga_final_0/opamp_2stage_final_0/m3_pmos_0/a_452_116# pga_final_0/opamp_2stage_final_0/m3_pmos_0/a_956_116# 0.19606f
C939 sh_final_0/opamp_2stage_final_0/m5_nmos_0/a_n1044_n2116# sh_final_0/opamp_2stage_final_0/m5_nmos_0/a_n956_n2208# 0.29587f
C940 pga_final_0/opamp_2stage_final_0/m4_pmos_0/a_n556_n4348# pga_final_0/opamp_2stage_final_0/m4_pmos_0/a_n956_n4440# 0.29587f
C941 sh_final_0/opamp_2stage_final_0/m3_pmos_0/a_n452_24# sh_final_0/opamp_2stage_final_0/m3_pmos_0/a_52_24# 0.05997f
C942 sh_final_0/opamp_2stage_final_0/m5_nmos_0/a_n956_n4440# sh_final_0/opamp_2stage_final_0/m5_nmos_0/a_n1044_n4348# 0.29587f
C943 sh_final_0/opamp_2stage_final_0/m2_7152_15850# sh_final_0/opamp_2stage_final_0/m6_pmos_0/a_n52_n8116# 0.05541f
C944 sh_final_0/opamp_2stage_final_0/m5_nmos_0/a_956_n2116# sh_final_0/opamp_2stage_final_0/m5_nmos_0/a_452_n2116# 0.19606f
C945 sh_final_0/opamp_2stage_final_0/m7_nmos_0/a_n52_4348# sh_final_0/opamp_2stage_final_0/m7_nmos_0/a_452_4348# 0.39251f
C946 pga_final_0/opamp_2stage_final_0/m3_pmos_0/w_n1220_n4604# pga_final_0/opamp_2stage_final_0/m3_pmos_0/a_n1044_116# 1.24508f
C947 sh_final_0/opamp_2stage_final_0/m1_nmos_0/a_n956_n8440# sh_final_0/opamp_2stage_final_0/m1_nmos_0/a_n556_n8348# 0.59234f
C948 sh_final_0/opamp_2stage_final_0/m4_pmos_0/a_n52_n4348# sh_final_0/opamp_2stage_final_0/m4_pmos_0/w_n1220_n4604# 0.47455f
C949 sh_final_0/opamp_2stage_final_0/m2_nmos_0/a_n52_n4116# sh_final_0/opamp_2stage_final_0/m2_nmos_0/a_452_n4116# 0.39251f
C950 pga_final_0/opamp_2stage_final_0/m1_nmos_0/a_52_4256# pga_final_0/opamp_2stage_final_0/m1_nmos_0/a_n452_4256# 0.05997f
C951 sh_final_0/opamp_2stage_final_0/m7_nmos_0/a_956_n8348# sh_final_0/opamp_2stage_final_0/m7_nmos_0/a_556_n8440# 0.59234f
C952 pga_final_0/opamp_2stage_final_0/m5_nmos_0/a_52_2256# pga_final_0/opamp_2stage_final_0/m5_nmos_0/a_556_2256# 0.05997f
C953 sh_final_0/opamp_2stage_final_0/m3_pmos_0/w_n1220_n4604# sh_final_0/opamp_2stage_final_0/m3_pmos_0/a_n452_n4440# 0.71938f
C954 pga_final_0/opamp_2stage_final_0/m4_pmos_0/a_n1044_2348# pga_final_0/opamp_2stage_final_0/m4_pmos_0/a_n556_2348# 0.19606f
C955 sh_final_0/opamp_2stage_final_0/m2_nmos_0/a_n452_24# sh_final_0/opamp_2stage_final_0/m2_nmos_0/a_52_24# 0.05997f
C956 sh_final_0/opamp_2stage_final_0/m3_pmos_0/a_556_n4440# sh_final_0/opamp_2stage_final_0/m3_pmos_0/w_n1220_n4604# 0.76217f
C957 pga_final_0/opamp_2stage_final_0/m4_pmos_0/a_n452_2256# pga_final_0/opamp_2stage_final_0/m4_pmos_0/a_n956_2256# 0.05997f
C958 bias_final_0/bias_nmos_0/a_n52_116# bias_final_0/bias_nmos_0/a_452_116# 0.15677f
C959 sh_final_0/opamp_2stage_final_0/m7_nmos_0/a_n52_116# sh_final_0/opamp_2stage_final_0/m7_nmos_0/a_n452_24# 0.59234f
C960 pga_final_0/opamp_2stage_final_0/m7_nmos_0/a_n556_116# pga_final_0/opamp_2stage_final_0/m7_nmos_0/a_n956_24# 0.59234f
C961 sh_final_0/opamp_2stage_final_0/m1_nmos_0/a_n452_n8440# sh_final_0/opamp_2stage_final_0/m1_nmos_0/a_n52_n8348# 0.59234f
C962 sh_final_0/opamp_2stage_final_0/m6_pmos_0/a_n356_n8116# sh_final_0/opamp_2stage_final_0/m6_pmos_0/a_n644_n8116# 1.43738f
C963 pga_final_0/opamp_2stage_final_0/m4_pmos_0/w_n1220_n4604# pga_final_0/opamp_2stage_final_0/m4_pmos_0/a_452_n2116# 0.45674f
C964 sh_final_0/opamp_2stage_final_0/m2_nmos_0/a_n452_4256# sh_final_0/opamp_2stage_final_0/m2_nmos_0/a_n956_4256# 0.05997f
C965 sh_final_0/opamp_2stage_final_0/m4_pmos_0/a_956_116# sh_final_0/opamp_2stage_final_0/m4_pmos_0/a_452_116# 0.19606f
C966 sh_final_0/opamp_2stage_final_0/m5_nmos_0/a_n452_24# sh_final_0/opamp_2stage_final_0/m5_nmos_0/a_n956_24# 0.05997f
C967 sh_final_0/opamp_2stage_final_0/m5_nmos_0/a_52_n2208# sh_final_0/opamp_2stage_final_0/m5_nmos_0/a_556_n2208# 0.05997f
C968 sh_final_0/opamp_2stage_final_0/m1_n2152_32500# sh_final_0/opamp_2stage_final_0/m6_pmos_0/a_52_n8208# 0.25049f
C969 sh_final_0/opamp_2stage_final_0/m1_nmos_0/a_n452_4256# sh_final_0/opamp_2stage_final_0/m1_nmos_0/a_52_4256# 0.05997f
C970 pga_final_0/opamp_2stage_final_0/m4_pmos_0/a_52_24# pga_final_0/opamp_2stage_final_0/m4_pmos_0/a_n52_116# 0.29587f
C971 pga_final_0/opamp_2stage_final_0/m7_nmos_0/a_n452_4256# pga_final_0/opamp_2stage_final_0/m7_nmos_0/a_n556_4348# 0.59234f
C972 pga_final_0/opamp_2stage_final_0/m1_nmos_0/a_452_n4116# pga_final_0/opamp_2stage_final_0/m1_nmos_0/a_956_n4116# 0.39251f
C973 pga_final_0/opamp_2stage_final_0/m1_nmos_0/a_452_4348# pga_final_0/opamp_2stage_final_0/m1_nmos_0/a_52_4256# 0.59234f
C974 sh_final_0/opamp_2stage_final_0/m7_nmos_0/a_n1044_116# sh_final_0/opamp_2stage_final_0/m7_nmos_0/a_n556_116# 0.39251f
C975 pga_final_0/opamp_2stage_final_0/m3_pmos_0/a_52_n2208# pga_final_0/opamp_2stage_final_0/m3_pmos_0/a_n452_n2208# 0.05997f
C976 pga_final_0/opamp_2stage_final_0/m5_nmos_0/a_52_2256# pga_final_0/opamp_2stage_final_0/m5_nmos_0/a_52_24# 0.37451f
C977 sh_final_0/opamp_2stage_final_0/m1_n2152_32500# sh_final_0/opamp_2stage_final_0/m6_pmos_0/a_n556_n16440# 2.24203f
C978 pga_final_0/opamp_2stage_final_0/m4_pmos_0/a_452_n4348# pga_final_0/opamp_2stage_final_0/m4_pmos_0/a_n52_n4348# 0.19606f
C979 pga_final_0/opamp_2stage_final_0/m6_pmos_0/a_n356_116# pga_final_0/opamp_2stage_final_0/m6_pmos_0/a_n556_24# 0.85436f
C980 pga_final_0/opamp_2stage_final_0/m6_pmos_0/a_356_24# pga_final_0/opamp_2stage_final_0/m6_pmos_0/a_52_24# 0.05997f
C981 sh_final_0/opamp_2stage_final_0/m2_nmos_0/a_n556_n4116# sh_final_0/opamp_2stage_final_0/m2_nmos_0/a_n452_n4208# 0.59234f
C982 sh_final_0/opamp_2stage_final_0/m1_nmos_0/a_n452_n8440# sh_final_0/opamp_2stage_final_0/m1_nmos_0/a_n452_n4208# 0.37451f
C983 bias_final_0/bias_nmos_0/a_452_116# bias_final_0/bias_nmos_0/a_52_24# 0.23658f
C984 sh_final_0/opamp_2stage_final_0/m7_nmos_0/a_556_n4208# sh_final_0/opamp_2stage_final_0/m7_nmos_0/a_452_n4116# 0.59234f
C985 sh_final_0/opamp_2stage_final_0/m4_pmos_0/a_n452_n4440# sh_final_0/opamp_2stage_final_0/m4_pmos_0/w_n1220_n4604# 0.71938f
C986 sh_final_0/opamp_2stage_final_0/m6_pmos_0/a_n356_n8116# sh_final_0/opamp_2stage_final_0/m6_pmos_0/a_n252_n8208# 0.85436f
C987 bias_final_0/bias_nmos_1/a_n52_116# bias_final_0/bias_nmos_1/a_452_116# 0.15677f
C988 sh_final_0/opamp_2stage_final_0/m4_pmos_0/a_n556_116# sh_final_0/opamp_2stage_final_0/m4_pmos_0/w_n1220_n4604# 0.45674f
C989 sh_final_0/opamp_2stage_final_0/m4_pmos_0/a_52_24# sh_final_0/opamp_2stage_final_0/m4_pmos_0/a_52_2256# 0.37451f
C990 sh_final_0/opamp_2stage_final_0/m3_pmos_0/a_n956_n4440# sh_final_0/opamp_2stage_final_0/m3_pmos_0/w_n1220_n4604# 0.76217f
C991 pga_final_0/opamp_2stage_final_0/m1_nmos_0/a_n956_4256# pga_final_0/opamp_2stage_final_0/m1_nmos_0/a_n452_4256# 0.05997f
C992 sh_final_0/opamp_2stage_final_0/m7_nmos_0/a_n556_116# sh_final_0/opamp_2stage_final_0/m7_nmos_0/a_n956_24# 0.59234f
C993 sh_final_0/opamp_2stage_final_0/m1_nmos_0/a_956_4348# sh_final_0/opamp_2stage_final_0/m1_nmos_0/a_452_4348# 0.39251f
C994 pga_final_0/opamp_2stage_final_0/m6_pmos_0/a_n556_8256# pga_final_0/opamp_2stage_final_0/m6_pmos_0/a_n556_24# 0.18596f
C995 pga_final_0/opamp_2stage_final_0/m7_nmos_0/a_n452_n8440# pga_final_0/opamp_2stage_final_0/m7_nmos_0/a_n556_n8348# 0.59234f
C996 pga_final_0/opamp_2stage_final_0/m3_pmos_0/a_n1044_116# pga_final_0/opamp_2stage_final_0/m3_pmos_0/a_n556_116# 0.19606f
C997 pga_final_0/opamp_2stage_final_0/m5_nmos_0/a_n452_24# pga_final_0/opamp_2stage_final_0/m5_nmos_0/a_n956_24# 0.05997f
C998 sh_final_0/opamp_2stage_final_0/m6_pmos_0/a_n252_n16440# sh_final_0/opamp_2stage_final_0/m6_pmos_0/a_n556_n16440# 0.05997f
C999 sh_final_0/opamp_2stage_final_0/m1_n2152_32500# sh_final_0/opamp_2stage_final_0/m6_pmos_0/a_n52_n8116# 1.30578f
C1000 sh_final_0/opamp_2stage_final_0/m7_nmos_0/a_n556_116# sh_final_0/opamp_2stage_final_0/m7_nmos_0/a_n452_24# 0.59234f
C1001 pga_final_0/opamp_2stage_final_0/m2_nmos_0/a_n556_4348# pga_final_0/opamp_2stage_final_0/m2_nmos_0/a_n956_4256# 0.59234f
C1002 sh_final_0/opamp_2stage_final_0/m3_pmos_0/a_n452_24# sh_final_0/opamp_2stage_final_0/m3_pmos_0/w_n1220_n4604# 0.45835f
C1003 sh_final_0/opamp_2stage_final_0/m5_nmos_0/a_452_116# sh_final_0/opamp_2stage_final_0/m5_nmos_0/a_556_24# 0.29587f
C1004 sh_final_0/opamp_2stage_final_0/m2_nmos_0/a_452_n8348# sh_final_0/opamp_2stage_final_0/m2_nmos_0/a_52_n8440# 0.59234f
C1005 pga_final_0/opamp_2stage_final_0/m4_pmos_0/w_n1220_n4604# pga_final_0/opamp_2stage_final_0/m4_pmos_0/a_n452_n2208# 0.45835f
C1006 sh_final_0/opamp_2stage_final_0/m5_nmos_0/a_556_n2208# sh_final_0/opamp_2stage_final_0/m5_nmos_0/a_556_n4440# 0.37451f
C1007 sh_final_0/opamp_2stage_final_0/m6_pmos_0/a_356_n8208# sh_final_0/opamp_2stage_final_0/m6_pmos_0/a_356_24# 0.18596f
C1008 sh_final_0/opamp_2stage_final_0/m3_pmos_0/a_n52_116# sh_final_0/opamp_2stage_final_0/m3_pmos_0/a_n556_116# 0.19606f
C1009 sh_final_0/opamp_2stage_final_0/m3_pmos_0/a_452_116# sh_final_0/opamp_2stage_final_0/m3_pmos_0/a_556_24# 0.29587f
C1010 pga_final_0/opamp_2stage_final_0/m3_pmos_0/a_n52_n4348# pga_final_0/opamp_2stage_final_0/m3_pmos_0/a_n556_n4348# 0.19606f
C1011 pga_final_0/opamp_2stage_final_0/m1_nmos_0/a_52_n8440# pga_final_0/opamp_2stage_final_0/m1_nmos_0/a_452_n8348# 0.59234f
C1012 pga_final_0/opamp_2stage_final_0/m3_pmos_0/a_52_n2208# pga_final_0/opamp_2stage_final_0/m3_pmos_0/a_556_n2208# 0.05997f
C1013 sh_final_0/opamp_2stage_final_0/m6_pmos_0/a_n52_116# sh_final_0/opamp_2stage_final_0/m6_pmos_0/a_252_116# 1.43738f
C1014 pga_final_0/opamp_2stage_final_0/m4_pmos_0/w_n1220_n4604# pga_final_0/opamp_2stage_final_0/m4_pmos_0/a_n556_116# 0.45674f
C1015 pga_final_0/opamp_2stage_final_0/m5_nmos_0/a_n956_n4440# pga_final_0/opamp_2stage_final_0/m5_nmos_0/a_n956_n2208# 0.37451f
C1016 pga_final_0/opamp_2stage_final_0/m2_nmos_0/a_n452_24# pga_final_0/opamp_2stage_final_0/m2_nmos_0/a_n452_n4208# 0.37451f
C1017 pga_final_0/opamp_2stage_final_0/m6_pmos_0/a_52_n8208# pga_final_0/opamp_2stage_final_0/m6_pmos_0/a_52_24# 0.18596f
C1018 sh_final_0/opamp_2stage_final_0/m3_pmos_0/a_452_2348# sh_final_0/opamp_2stage_final_0/m3_pmos_0/w_n1220_n4604# 0.47456f
C1019 sh_final_0/opamp_2stage_final_0/m3_pmos_0/a_556_24# sh_final_0/opamp_2stage_final_0/m3_pmos_0/a_52_24# 0.05997f
C1020 pga_final_0/opamp_2stage_final_0/m3_pmos_0/a_n1044_n4348# pga_final_0/opamp_2stage_final_0/m3_pmos_0/a_n556_n4348# 0.19606f
C1021 sh_final_0/opamp_2stage_final_0/m4_pmos_0/a_n556_116# sh_final_0/opamp_2stage_final_0/m4_pmos_0/a_n452_24# 0.29587f
C1022 sh_final_0/opamp_2stage_final_0/m6_pmos_0/a_556_116# sh_final_0/opamp_2stage_final_0/m6_pmos_0/a_356_24# 0.85436f
C1023 pga_final_0/opamp_2stage_final_0/m1_nmos_0/a_452_n8348# pga_final_0/opamp_2stage_final_0/m1_nmos_0/a_556_n8440# 0.59234f
C1024 pga_final_0/opamp_2stage_final_0/m4_pmos_0/a_n452_2256# pga_final_0/opamp_2stage_final_0/m4_pmos_0/a_n452_24# 0.37451f
C1025 sh_final_0/opamp_2stage_final_0/m3_pmos_0/a_52_n2208# sh_final_0/opamp_2stage_final_0/m3_pmos_0/a_n452_n2208# 0.05997f
C1026 sh_final_0/opamp_2stage_final_0/m4_pmos_0/a_n52_n2116# sh_final_0/opamp_2stage_final_0/m4_pmos_0/a_52_n2208# 0.29587f
C1027 sh_final_0/opamp_2stage_final_0/m6_pmos_0/a_n52_116# sh_final_0/opamp_2stage_final_0/m6_pmos_0/a_n356_116# 1.43738f
C1028 pga_final_0/opamp_2stage_final_0/m5_nmos_0/a_452_2348# pga_final_0/opamp_2stage_final_0/m5_nmos_0/a_n52_2348# 0.19606f
C1029 pga_final_0/opamp_2stage_final_0/m2_nmos_0/a_n556_116# pga_final_0/opamp_2stage_final_0/m2_nmos_0/a_n52_116# 0.39251f
C1030 sh_final_0/opamp_2stage_final_0/m1_nmos_0/a_452_116# sh_final_0/opamp_2stage_final_0/m1_nmos_0/a_556_24# 0.59234f
C1031 sh_final_0/opamp_2stage_final_0/m4_pmos_0/a_956_n2116# sh_final_0/opamp_2stage_final_0/m4_pmos_0/w_n1220_n4604# 1.24508f
C1032 sh_final_0/opamp_2stage_final_0/m2_nmos_0/a_452_4348# sh_final_0/opamp_2stage_final_0/m2_nmos_0/a_956_4348# 0.39251f
C1033 sh_final_0/opamp_2stage_final_0/m6_pmos_0/a_n556_n8208# sh_final_0/opamp_2stage_final_0/m6_pmos_0/a_n644_n8116# 0.85436f
C1034 bias_final_0/bias_nmos_1/a_n452_24# bias_final_0/bias_nmos_1/a_n540_116# 0.23658f
C1035 pga_final_0/opamp_2stage_final_0/m3_pmos_0/a_n956_n4440# pga_final_0/opamp_2stage_final_0/m3_pmos_0/a_n956_n2208# 0.37451f
C1036 sh_final_0/opamp_2stage_final_0/m1_n2152_32500# sh_final_0/opamp_2stage_final_0/m6_pmos_0/a_356_24# 0.29156f
C1037 pga_final_0/opamp_2stage_final_0/m4_pmos_0/a_452_116# pga_final_0/opamp_2stage_final_0/m4_pmos_0/a_n52_116# 0.19606f
C1038 pga_final_0/opamp_2stage_final_0/m3_pmos_0/a_n52_116# pga_final_0/opamp_2stage_final_0/m3_pmos_0/a_n452_24# 0.29587f
C1039 sh_final_0/opamp_2stage_final_0/m4_pmos_0/a_n556_2348# sh_final_0/opamp_2stage_final_0/m4_pmos_0/w_n1220_n4604# 0.47456f
C1040 sh_final_0/opamp_2stage_final_0/m4_pmos_0/a_n1044_2348# sh_final_0/opamp_2stage_final_0/m4_pmos_0/a_n956_2256# 0.29587f
C1041 sh_final_0/opamp_2stage_final_0/m6_pmos_0/a_n252_8256# sh_final_0/opamp_2stage_final_0/m6_pmos_0/a_n556_8256# 0.05997f
C1042 pga_final_0/opamp_2stage_final_0/m7_nmos_0/a_n452_n4208# pga_final_0/opamp_2stage_final_0/m7_nmos_0/a_n956_n4208# 0.05997f
C1043 pga_final_0/opamp_2stage_final_0/m4_pmos_0/a_n52_n2116# pga_final_0/opamp_2stage_final_0/m4_pmos_0/a_452_n2116# 0.19606f
C1044 sh_final_0/opamp_2stage_final_0/m4_pmos_0/a_556_n2208# sh_final_0/opamp_2stage_final_0/m4_pmos_0/a_556_24# 0.37451f
C1045 pga_final_0/opamp_2stage_final_0/m3_pmos_0/a_n556_2348# pga_final_0/opamp_2stage_final_0/m3_pmos_0/a_n452_2256# 0.29587f
C1046 pga_final_0/opamp_2stage_final_0/m3_pmos_0/w_n1220_n4604# pga_final_0/opamp_2stage_final_0/m3_pmos_0/a_n556_116# 0.45674f
C1047 sh_final_0/opamp_2stage_final_0/m7_nmos_0/a_52_24# sh_final_0/opamp_2stage_final_0/m7_nmos_0/a_n452_24# 0.05997f
C1048 pga_final_0/opamp_2stage_final_0/m2_nmos_0/a_n452_24# pga_final_0/opamp_2stage_final_0/m2_nmos_0/a_n52_116# 0.59234f
C1049 sh_final_0/opamp_2stage_final_0/m6_pmos_0/a_n556_n8208# sh_final_0/opamp_2stage_final_0/m6_pmos_0/a_n252_n8208# 0.05997f
C1050 pga_final_0/opamp_2stage_final_0/m3_pmos_0/w_n1220_n4604# pga_final_0/opamp_2stage_final_0/m3_pmos_0/a_52_24# 0.45835f
C1051 pga_final_0/opamp_2stage_final_0/m5_nmos_0/a_n556_116# pga_final_0/opamp_2stage_final_0/m5_nmos_0/a_n1044_116# 0.19606f
C1052 pga_final_0/opamp_2stage_final_0/m7_nmos_0/a_956_116# pga_final_0/opamp_2stage_final_0/m7_nmos_0/a_452_116# 0.39251f
C1053 pga_final_0/opamp_2stage_final_0/m2_nmos_0/a_n452_n4208# pga_final_0/opamp_2stage_final_0/m2_nmos_0/a_52_n4208# 0.05997f
C1054 pga_final_0/opamp_2stage_final_0/m2_nmos_0/a_n556_4348# pga_final_0/opamp_2stage_final_0/m2_nmos_0/a_n1044_4348# 0.39251f
C1055 sh_final_0/opamp_2stage_final_0/m3_pmos_0/a_52_n4440# sh_final_0/opamp_2stage_final_0/m3_pmos_0/a_n452_n4440# 0.05997f
C1056 sh_final_0/opamp_2stage_final_0/m7_nmos_0/a_n1044_4348# sh_final_0/opamp_2stage_final_0/m7_nmos_0/a_n556_4348# 0.39251f
C1057 sh_final_0/opamp_2stage_final_0/m1_nmos_0/a_452_n8348# sh_final_0/opamp_2stage_final_0/m1_nmos_0/a_52_n8440# 0.59234f
C1058 sh_final_0/opamp_2stage_final_0/m3_pmos_0/a_556_n2208# sh_final_0/opamp_2stage_final_0/m3_pmos_0/a_956_n2116# 0.29587f
C1059 pga_final_0/opamp_2stage_final_0/m5_nmos_0/a_956_n2116# pga_final_0/opamp_2stage_final_0/m5_nmos_0/a_556_n2208# 0.29587f
C1060 pga_final_0/opamp_2stage_final_0/m5_nmos_0/a_n52_n2116# pga_final_0/opamp_2stage_final_0/m5_nmos_0/a_n556_n2116# 0.19606f
C1061 pga_final_0/opamp_2stage_final_0/m4_pmos_0/w_n1220_n4604# pga_final_0/opamp_2stage_final_0/m4_pmos_0/a_n52_2348# 0.47455f
C1062 sh_final_0/opamp_2stage_final_0/m2_nmos_0/a_n1044_116# sh_final_0/opamp_2stage_final_0/m2_nmos_0/a_n956_24# 0.59234f
C1063 pga_final_0/opamp_2stage_final_0/m2_nmos_0/a_452_4348# pga_final_0/opamp_2stage_final_0/m2_nmos_0/a_556_4256# 0.59234f
C1064 sh_final_0/opamp_2stage_final_0/m3_pmos_0/a_556_n4440# sh_final_0/opamp_2stage_final_0/m3_pmos_0/a_52_n4440# 0.05997f
C1065 pga_final_0/opamp_2stage_final_0/m4_pmos_0/a_n52_n2116# pga_final_0/opamp_2stage_final_0/m4_pmos_0/a_n452_n2208# 0.29587f
C1066 sh_final_0/opamp_2stage_final_0/m5_nmos_0/a_n1044_n2116# sh_final_0/opamp_2stage_final_0/m5_nmos_0/a_n556_n2116# 0.19606f
C1067 pga_final_0/opamp_2stage_final_0/m1_nmos_0/a_n956_n8440# pga_final_0/opamp_2stage_final_0/m1_nmos_0/a_n956_n4208# 0.37451f
C1068 pga_final_0/opamp_2stage_final_0/m3_pmos_0/a_452_n2116# pga_final_0/opamp_2stage_final_0/m3_pmos_0/a_556_n2208# 0.29587f
C1069 sh_final_0/opamp_2stage_final_0/m4_pmos_0/a_956_2348# sh_final_0/opamp_2stage_final_0/m4_pmos_0/a_452_2348# 0.19606f
C1070 sh_final_0/opamp_2stage_final_0/m6_pmos_0/a_52_24# sh_final_0/opamp_2stage_final_0/m6_pmos_0/a_52_8256# 0.18596f
C1071 sh_final_0/opamp_2stage_final_0/m1_nmos_0/a_n556_n4116# sh_final_0/opamp_2stage_final_0/m1_nmos_0/a_n956_n4208# 0.59234f
C1072 sh_final_0/opamp_2stage_final_0/m5_nmos_0/a_n52_n2116# sh_final_0/opamp_2stage_final_0/m5_nmos_0/a_52_n2208# 0.29587f
C1073 sh_final_0/opamp_2stage_final_0/m2_nmos_0/a_452_116# sh_final_0/opamp_2stage_final_0/m2_nmos_0/a_n52_116# 0.39251f
C1074 sh_final_0/opamp_2stage_final_0/m3_pmos_0/w_n1220_n4604# sh_final_0/opamp_2stage_final_0/m3_pmos_0/a_556_24# 0.50114f
C1075 pga_final_0/opamp_2stage_final_0/m2_nmos_0/a_452_116# pga_final_0/opamp_2stage_final_0/m2_nmos_0/a_956_116# 0.39251f
C1076 sh_final_0/opamp_2stage_final_0/m5_nmos_0/a_52_24# sh_final_0/opamp_2stage_final_0/m5_nmos_0/a_556_24# 0.05997f
C1077 pga_final_0/opamp_2stage_final_0/m1_nmos_0/a_n556_4348# pga_final_0/opamp_2stage_final_0/m1_nmos_0/a_n452_4256# 0.59234f
C1078 pga_final_0/opamp_2stage_final_0/m4_pmos_0/a_n52_n2116# pga_final_0/opamp_2stage_final_0/m4_pmos_0/w_n1220_n4604# 0.45673f
C1079 pga_final_0/opamp_2stage_final_0/m5_nmos_0/a_452_2348# pga_final_0/opamp_2stage_final_0/m5_nmos_0/a_52_2256# 0.29587f
C1080 pga_final_0/opamp_2stage_final_0/m4_pmos_0/a_52_n4440# pga_final_0/opamp_2stage_final_0/m4_pmos_0/a_n452_n4440# 0.05997f
C1081 pga_final_0/opamp_2stage_final_0/m2_nmos_0/a_556_n4208# pga_final_0/opamp_2stage_final_0/m2_nmos_0/a_556_24# 0.37451f
C1082 pga_final_0/opamp_2stage_final_0/m1_nmos_0/a_52_n8440# pga_final_0/opamp_2stage_final_0/m1_nmos_0/a_n52_n8348# 0.59234f
C1083 pga_final_0/opamp_2stage_final_0/m7_nmos_0/a_452_116# pga_final_0/opamp_2stage_final_0/m7_nmos_0/a_556_24# 0.59234f
C1084 sh_final_0/opamp_2stage_final_0/m5_nmos_0/a_52_n2208# sh_final_0/opamp_2stage_final_0/m5_nmos_0/a_452_n2116# 0.29587f
C1085 pga_final_0/opamp_2stage_final_0/m6_pmos_0/a_n556_8256# pga_final_0/opamp_2stage_final_0/m6_pmos_0/a_n252_8256# 0.05997f
C1086 pga_final_0/opamp_2stage_final_0/m2_nmos_0/a_n52_n8348# pga_final_0/opamp_2stage_final_0/m2_nmos_0/a_n452_n8440# 0.59234f
C1087 pga_final_0/opamp_2stage_final_0/m2_nmos_0/a_956_116# pga_final_0/opamp_2stage_final_0/m2_nmos_0/a_556_24# 0.59234f
C1088 pga_final_0/opamp_2stage_final_0/m7_nmos_0/a_n52_n4116# pga_final_0/opamp_2stage_final_0/m7_nmos_0/a_n452_n4208# 0.59234f
C1089 sh_final_0/opamp_2stage_final_0/m3_pmos_0/a_n956_n2208# sh_final_0/opamp_2stage_final_0/m3_pmos_0/a_n556_n2116# 0.29587f
C1090 pga_final_0/opamp_2stage_final_0/m6_pmos_0/a_252_n8116# pga_final_0/opamp_2stage_final_0/m6_pmos_0/a_356_n8208# 0.85436f
C1091 sh_final_0/opamp_2stage_final_0/m2_nmos_0/a_556_24# sh_final_0/opamp_2stage_final_0/m2_nmos_0/a_556_4256# 0.37451f
C1092 sh_final_0/opamp_2stage_final_0/m5_nmos_0/a_52_2256# sh_final_0/opamp_2stage_final_0/m5_nmos_0/a_556_2256# 0.05997f
C1093 pga_final_0/opamp_2stage_final_0/m3_pmos_0/a_n452_24# pga_final_0/opamp_2stage_final_0/m3_pmos_0/a_n452_2256# 0.37451f
C1094 pga_final_0/opamp_2stage_final_0/m1_nmos_0/a_n556_116# pga_final_0/opamp_2stage_final_0/m1_nmos_0/a_n52_116# 0.39251f
C1095 pga_final_0/opamp_2stage_final_0/m3_pmos_0/a_52_2256# pga_final_0/opamp_2stage_final_0/m3_pmos_0/a_n52_2348# 0.29587f
C1096 sh_final_0/opamp_2stage_final_0/m7_nmos_0/a_n956_n4208# sh_final_0/opamp_2stage_final_0/m7_nmos_0/a_n452_n4208# 0.05997f
C1097 sh_final_0/opamp_2stage_final_0/m4_pmos_0/a_452_n2116# sh_final_0/opamp_2stage_final_0/m4_pmos_0/a_556_n2208# 0.29587f
C1098 sh_final_0/opamp_2stage_final_0/m5_nmos_0/a_n452_n2208# sh_final_0/opamp_2stage_final_0/m5_nmos_0/a_n956_n2208# 0.05997f
C1099 pga_final_0/opamp_2stage_final_0/m1_nmos_0/a_452_n4116# pga_final_0/opamp_2stage_final_0/m1_nmos_0/a_n52_n4116# 0.39251f
C1100 pga_final_0/opamp_2stage_final_0/m3_pmos_0/a_n1044_n4348# pga_final_0/opamp_2stage_final_0/m3_pmos_0/a_n956_n4440# 0.29587f
C1101 pga_final_0/opamp_2stage_final_0/m7_nmos_0/a_n52_n4116# pga_final_0/opamp_2stage_final_0/m7_nmos_0/a_52_n4208# 0.59234f
C1102 pga_final_0/opamp_2stage_final_0/m6_pmos_0/a_n52_116# pga_final_0/opamp_2stage_final_0/m6_pmos_0/a_52_24# 0.85436f
C1103 sh_final_0/opamp_2stage_final_0/m7_nmos_0/a_n556_n8348# sh_final_0/opamp_2stage_final_0/m7_nmos_0/a_n1044_n8348# 0.39251f
C1104 pga_final_0/opamp_2stage_final_0/m4_pmos_0/a_n1044_116# pga_final_0/opamp_2stage_final_0/m4_pmos_0/a_n956_24# 0.29587f
C1105 pga_final_0/opamp_2stage_final_0/m7_nmos_0/a_556_n4208# pga_final_0/opamp_2stage_final_0/m7_nmos_0/a_556_n8440# 0.37451f
C1106 pga_final_0/opamp_2stage_final_0/m4_pmos_0/a_956_116# pga_final_0/opamp_2stage_final_0/m4_pmos_0/w_n1220_n4604# 1.24508f
C1107 sh_final_0/opamp_2stage_final_0/m4_pmos_0/a_956_116# sh_final_0/opamp_2stage_final_0/m4_pmos_0/w_n1220_n4604# 1.24508f
C1108 pga_final_0/opamp_2stage_final_0/m7_nmos_0/a_n452_n4208# pga_final_0/opamp_2stage_final_0/m7_nmos_0/a_n452_24# 0.37451f
C1109 sh_final_0/opamp_2stage_final_0/m3_pmos_0/a_452_2348# sh_final_0/opamp_2stage_final_0/m3_pmos_0/a_556_2256# 0.29587f
C1110 pga_final_0/opamp_2stage_final_0/m1_nmos_0/a_n52_116# pga_final_0/opamp_2stage_final_0/m1_nmos_0/a_n452_24# 0.59234f
C1111 pga_final_0/opamp_2stage_final_0/m5_nmos_0/a_n956_24# pga_final_0/opamp_2stage_final_0/m5_nmos_0/a_n1044_116# 0.29587f
C1112 pga_final_0/opamp_2stage_final_0/m7_nmos_0/a_452_n4116# pga_final_0/opamp_2stage_final_0/m7_nmos_0/a_52_n4208# 0.59234f
C1113 sh_final_0/opamp_2stage_final_0/m2_nmos_0/a_n956_n4208# sh_final_0/opamp_2stage_final_0/m2_nmos_0/a_n956_24# 0.37451f
C1114 sh_final_0/opamp_2stage_final_0/m3_pmos_0/a_52_n2208# sh_final_0/opamp_2stage_final_0/m3_pmos_0/a_556_n2208# 0.05997f
C1115 pga_final_0/opamp_2stage_final_0/m1_nmos_0/a_452_n4116# pga_final_0/opamp_2stage_final_0/m1_nmos_0/a_556_n4208# 0.59234f
C1116 sh_final_0/opamp_2stage_final_0/m3_pmos_0/a_n1044_n2116# sh_final_0/opamp_2stage_final_0/m3_pmos_0/a_n956_n2208# 0.29587f
C1117 pga_final_0/opamp_2stage_final_0/m1_nmos_0/a_n52_n4116# pga_final_0/opamp_2stage_final_0/m1_nmos_0/a_n556_n4116# 0.39251f
C1118 pga_final_0/opamp_2stage_final_0/m7_nmos_0/a_n52_116# pga_final_0/opamp_2stage_final_0/m7_nmos_0/a_n452_24# 0.59234f
C1119 pga_final_0/opamp_2stage_final_0/m3_pmos_0/a_556_n4440# pga_final_0/opamp_2stage_final_0/m3_pmos_0/a_556_n2208# 0.37451f
C1120 pga_final_0/opamp_2stage_final_0/m7_nmos_0/a_556_n4208# pga_final_0/opamp_2stage_final_0/m7_nmos_0/a_52_n4208# 0.05997f
C1121 sh_final_0/opamp_2stage_final_0/m6_pmos_0/a_356_n8208# sh_final_0/opamp_2stage_final_0/m6_pmos_0/a_356_n16440# 0.18596f
C1122 pga_final_0/opamp_2stage_final_0/m2_7152_15850# pga_final_0/opamp_2stage_final_0/m6_pmos_0/a_n252_n8208# 0.08782f
C1123 sh_final_0/opamp_2stage_final_0/m3_pmos_0/a_n452_24# sh_final_0/opamp_2stage_final_0/m3_pmos_0/a_n956_24# 0.05997f
C1124 sh_final_0/opamp_2stage_final_0/m4_pmos_0/a_556_n4440# sh_final_0/opamp_2stage_final_0/m4_pmos_0/a_956_n4348# 0.29587f
C1125 pga_final_0/opamp_2stage_final_0/m4_pmos_0/w_n1220_n4604# pga_final_0/opamp_2stage_final_0/m4_pmos_0/a_n52_n4348# 0.47455f
C1126 sh_final_0/opamp_2stage_final_0/m4_pmos_0/a_52_n2208# sh_final_0/opamp_2stage_final_0/m4_pmos_0/w_n1220_n4604# 0.45835f
C1127 sh_final_0/opamp_2stage_final_0/m6_pmos_0/a_356_n8208# sh_final_0/opamp_2stage_final_0/m6_pmos_0/a_252_n8116# 0.85436f
C1128 pga_final_0/opamp_2stage_final_0/m5_nmos_0/a_n1044_2348# pga_final_0/opamp_2stage_final_0/m5_nmos_0/a_n956_2256# 0.29587f
C1129 pga_final_0/opamp_2stage_final_0/m1_nmos_0/a_556_n4208# pga_final_0/opamp_2stage_final_0/m1_nmos_0/a_956_n4116# 0.59234f
C1130 sh_final_0/opamp_2stage_final_0/m7_nmos_0/a_n556_4348# sh_final_0/opamp_2stage_final_0/m7_nmos_0/a_n956_4256# 0.59234f
C1131 pga_final_0/opamp_2stage_final_0/m7_nmos_0/a_52_4256# pga_final_0/opamp_2stage_final_0/m7_nmos_0/a_556_4256# 0.05997f
C1132 pga_final_0/opamp_2stage_final_0/m2_nmos_0/a_52_24# pga_final_0/opamp_2stage_final_0/m2_nmos_0/a_452_116# 0.59234f
C1133 pga_final_0/opamp_2stage_final_0/m6_pmos_0/a_n252_n8208# pga_final_0/opamp_2stage_final_0/m6_pmos_0/a_n556_n8208# 0.05997f
C1134 pga_final_0/opamp_2stage_final_0/m3_pmos_0/w_n1220_n4604# pga_final_0/opamp_2stage_final_0/m3_pmos_0/a_956_n2116# 1.24508f
C1135 sh_final_0/opamp_2stage_final_0/m7_nmos_0/a_956_n4116# sh_final_0/opamp_2stage_final_0/m7_nmos_0/a_452_n4116# 0.39251f
C1136 sh_final_0/opamp_2stage_final_0/m2_nmos_0/a_956_4348# sh_final_0/opamp_2stage_final_0/m2_nmos_0/a_556_4256# 0.59234f
C1137 pga_final_0/opamp_2stage_final_0/m7_nmos_0/a_52_4256# pga_final_0/opamp_2stage_final_0/m7_nmos_0/a_52_24# 0.37451f
C1138 pga_final_0/opamp_2stage_final_0/m5_nmos_0/a_n1044_n2116# pga_final_0/opamp_2stage_final_0/m5_nmos_0/a_n956_n2208# 0.29587f
C1139 sh_final_0/opamp_2stage_final_0/m7_nmos_0/a_452_4348# sh_final_0/opamp_2stage_final_0/m7_nmos_0/a_556_4256# 0.59234f
C1140 sh_final_0/opamp_2stage_final_0/m4_pmos_0/a_n52_n4348# sh_final_0/opamp_2stage_final_0/m4_pmos_0/a_n452_n4440# 0.29587f
C1141 sh_final_0/opamp_2stage_final_0/m3_pmos_0/a_n52_n2116# sh_final_0/opamp_2stage_final_0/m3_pmos_0/a_n452_n2208# 0.29587f
C1142 pga_final_0/opamp_2stage_final_0/m5_nmos_0/a_n52_n4348# pga_final_0/opamp_2stage_final_0/m5_nmos_0/a_52_n4440# 0.29587f
C1143 pga_final_0/opamp_2stage_final_0/m5_nmos_0/a_52_n2208# pga_final_0/opamp_2stage_final_0/m5_nmos_0/a_52_24# 0.37451f
C1144 pga_final_0/opamp_2stage_final_0/m4_pmos_0/a_n1044_n2116# pga_final_0/opamp_2stage_final_0/m4_pmos_0/w_n1220_n4604# 1.24508f
C1145 sh_final_0/opamp_2stage_final_0/m1_nmos_0/a_956_116# sh_final_0/opamp_2stage_final_0/m1_nmos_0/a_452_116# 0.39251f
C1146 sh_final_0/opamp_2stage_final_0/m4_pmos_0/a_556_n4440# sh_final_0/opamp_2stage_final_0/m4_pmos_0/w_n1220_n4604# 0.76217f
C1147 pga_final_0/opamp_2stage_final_0/m3_pmos_0/a_556_n2208# pga_final_0/opamp_2stage_final_0/m3_pmos_0/a_556_24# 0.37451f
C1148 sh_final_0/opamp_2stage_final_0/m3_pmos_0/a_n1044_2348# sh_final_0/opamp_2stage_final_0/m3_pmos_0/a_n956_2256# 0.29587f
C1149 pga_final_0/opamp_2stage_final_0/m2_nmos_0/a_52_24# pga_final_0/opamp_2stage_final_0/m2_nmos_0/a_556_24# 0.05997f
C1150 sh_final_0/opamp_2stage_final_0/m3_pmos_0/a_956_116# sh_final_0/opamp_2stage_final_0/m3_pmos_0/a_556_24# 0.29587f
C1151 sh_final_0/opamp_2stage_final_0/m4_pmos_0/a_956_2348# sh_final_0/opamp_2stage_final_0/m4_pmos_0/w_n1220_n4604# 1.26104f
C1152 sh_final_0/opamp_2stage_final_0/m4_pmos_0/a_n52_2348# sh_final_0/opamp_2stage_final_0/m4_pmos_0/a_n452_2256# 0.29587f
C1153 pga_final_0/opamp_2stage_final_0/m7_nmos_0/a_n556_116# pga_final_0/opamp_2stage_final_0/m7_nmos_0/a_n52_116# 0.39251f
C1154 pga_final_0/opamp_2stage_final_0/m3_pmos_0/w_n1220_n4604# pga_final_0/opamp_2stage_final_0/m3_pmos_0/a_452_n4348# 0.47456f
C1155 sh_final_0/opamp_2stage_final_0/m7_nmos_0/a_n52_n4116# sh_final_0/opamp_2stage_final_0/m7_nmos_0/a_452_n4116# 0.39251f
C1156 sh_final_0/opamp_2stage_final_0/m1_n2152_32500# sh_final_0/opamp_2stage_final_0/m6_pmos_0/a_356_n16440# 2.24203f
C1157 pga_final_0/opamp_2stage_final_0/m3_pmos_0/w_n1220_n4604# pga_final_0/opamp_2stage_final_0/m3_pmos_0/a_52_n4440# 0.71938f
C1158 sh_final_0/opamp_2stage_final_0/m2_nmos_0/a_452_4348# sh_final_0/opamp_2stage_final_0/m2_nmos_0/a_52_4256# 0.59234f
C1159 sh_final_0/opamp_2stage_final_0/m1_n2152_32500# sh_final_0/opamp_2stage_final_0/m6_pmos_0/a_252_n8116# 1.30581f
C1160 pga_final_0/opamp_2stage_final_0/m2_7152_15850# pga_final_0/opamp_2stage_final_0/m6_pmos_0/a_n356_n8116# 0.09705f
C1161 sh_final_0/opamp_2stage_final_0/m3_pmos_0/a_556_24# sh_final_0/opamp_2stage_final_0/m3_pmos_0/a_556_2256# 0.37451f
C1162 pga_final_0/opamp_2stage_final_0/m3_pmos_0/a_n52_n4348# pga_final_0/opamp_2stage_final_0/m3_pmos_0/a_n452_n4440# 0.29587f
C1163 sh_final_0/opamp_2stage_final_0/m7_nmos_0/a_n556_n8348# sh_final_0/opamp_2stage_final_0/m7_nmos_0/a_n956_n8440# 0.59234f
C1164 sh_final_0/opamp_2stage_final_0/m3_pmos_0/a_n1044_n2116# sh_final_0/opamp_2stage_final_0/m3_pmos_0/a_n556_n2116# 0.19606f
C1165 sh_final_0/opamp_2stage_final_0/m6_pmos_0/a_n356_n8116# sh_final_0/opamp_2stage_final_0/m6_pmos_0/a_n52_n8116# 1.43738f
C1166 pga_final_0/opamp_2stage_final_0/m6_pmos_0/a_n356_n8116# pga_final_0/opamp_2stage_final_0/m6_pmos_0/a_n556_n8208# 0.85436f
C1167 sh_final_0/opamp_2stage_final_0/m1_nmos_0/a_n52_n8348# sh_final_0/opamp_2stage_final_0/m1_nmos_0/a_52_n8440# 0.59234f
C1168 sh_final_0/opamp_2stage_final_0/m4_pmos_0/a_452_116# sh_final_0/opamp_2stage_final_0/m4_pmos_0/a_556_24# 0.29587f
C1169 pga_final_0/opamp_2stage_final_0/m1_nmos_0/a_452_n4116# pga_final_0/opamp_2stage_final_0/m1_nmos_0/a_52_n4208# 0.59234f
C1170 pga_final_0/opamp_2stage_final_0/m7_nmos_0/a_n956_n8440# pga_final_0/opamp_2stage_final_0/m7_nmos_0/a_n452_n8440# 0.05997f
C1171 vref_final_0/vref_nmos_0/a_n400_n292# vref_final_0/vref_nmos_0/a_400_n200# 0.07019f
C1172 pga_final_0/opamp_2stage_final_0/m7_nmos_0/a_556_4256# pga_final_0/opamp_2stage_final_0/m7_nmos_0/a_452_4348# 0.59234f
C1173 pga_final_0/opamp_2stage_final_0/m2_nmos_0/a_n956_24# pga_final_0/opamp_2stage_final_0/m2_nmos_0/a_n956_4256# 0.37451f
C1174 sh_final_0/opamp_2stage_final_0/m4_pmos_0/a_n556_n4348# sh_final_0/opamp_2stage_final_0/m4_pmos_0/a_n956_n4440# 0.29587f
C1175 sh_final_0/opamp_2stage_final_0/m1_n2152_32500# sh_final_0/opamp_2stage_final_0/m6_pmos_0/a_n52_116# 1.3092f
C1176 sh_final_0/opamp_2stage_final_0/m2_nmos_0/a_n452_24# sh_final_0/opamp_2stage_final_0/m2_nmos_0/a_n452_n4208# 0.37451f
C1177 pga_final_0/opamp_2stage_final_0/m7_nmos_0/a_956_116# pga_final_0/opamp_2stage_final_0/m7_nmos_0/a_556_24# 0.59234f
C1178 pga_final_0/opamp_2stage_final_0/m4_pmos_0/a_556_n2208# pga_final_0/opamp_2stage_final_0/m4_pmos_0/a_956_n2116# 0.29587f
C1179 pga_final_0/opamp_2stage_final_0/m4_pmos_0/w_n1220_n4604# pga_final_0/opamp_2stage_final_0/m4_pmos_0/a_n956_2256# 0.76217f
C1180 pga_final_0/opamp_2stage_final_0/m4_pmos_0/a_n1044_n4348# pga_final_0/opamp_2stage_final_0/m4_pmos_0/a_n956_n4440# 0.29587f
C1181 pga_final_0/opamp_2stage_final_0/m3_pmos_0/a_n956_n2208# pga_final_0/opamp_2stage_final_0/m3_pmos_0/a_n452_n2208# 0.05997f
C1182 sh_final_0/opamp_2stage_final_0/m7_nmos_0/a_556_n4208# sh_final_0/opamp_2stage_final_0/m7_nmos_0/a_956_n4116# 0.59234f
C1183 sh_final_0/opamp_2stage_final_0/m2_nmos_0/a_n52_116# sh_final_0/opamp_2stage_final_0/m2_nmos_0/a_52_24# 0.59234f
C1184 pga_final_0/opamp_2stage_final_0/m3_pmos_0/a_n452_24# pga_final_0/opamp_2stage_final_0/m3_pmos_0/a_n956_24# 0.05997f
C1185 sh_final_0/opamp_2stage_final_0/m5_nmos_0/a_n556_116# sh_final_0/opamp_2stage_final_0/m5_nmos_0/a_n52_116# 0.19606f
C1186 sh_final_0/opamp_2stage_final_0/m1_nmos_0/a_956_4348# sh_final_0/opamp_2stage_final_0/m1_nmos_0/a_556_4256# 0.59234f
C1187 sh_final_0/opamp_2stage_final_0/m1_n2152_32500# sh_final_0/opamp_2stage_final_0/m6_pmos_0/a_356_8256# 2.58045f
C1188 pga_final_0/opamp_2stage_final_0/m6_pmos_0/a_52_24# pga_final_0/opamp_2stage_final_0/m6_pmos_0/a_52_8256# 0.18596f
C1189 sh_final_0/opamp_2stage_final_0/m6_pmos_0/a_n556_24# sh_final_0/opamp_2stage_final_0/m6_pmos_0/a_n556_8256# 0.18596f
C1190 TEST VSUBS 48.0072f **FLOATING
C1191 VBN VSUBS 48.0072f **FLOATING
C1192 VREF VSUBS 48.0072f **FLOATING
C1193 GAIN2 VSUBS 48.0072f **FLOATING
C1194 GAIN1 VSUBS 48.0072f **FLOATING
C1195 GAIN0 VSUBS 48.0072f **FLOATING
C1196 PHI1A VSUBS 48.0072f **FLOATING
C1197 PHI1 VSUBS 48.0072f **FLOATING
C1198 VOUT VSUBS 48.0072f **FLOATING
C1199 VINP VSUBS 48.0072f **FLOATING
C1200 VSS VSUBS 48.0072f **FLOATING
C1201 VDD VSUBS 48.0072f **FLOATING
C1202 vref_final_0/m2_n100_0# VSUBS 1.74671f
C1203 vref_final_0/m2_n100_7600# VSUBS 0.75795f **FLOATING
C1204 vref_final_0/m2_n100_12600# VSUBS 0.75795f **FLOATING
C1205 vref_final_0/vref_nmos_0/a_400_n200# VSUBS 0.23277f **FLOATING
C1206 vref_final_0/vref_nmos_0/a_n488_n200# VSUBS 0.23277f **FLOATING
C1207 vref_final_0/vref_nmos_0/a_n400_n292# VSUBS 1.90656f **FLOATING
C1208 vref_final_0/r_vref_2/a_n200_n1902# VSUBS 0.52654f **FLOATING
C1209 vref_final_0/r_vref_2/a_n200_1800# VSUBS 0.52672f **FLOATING
C1210 vref_final_0/r_vref_1/a_n200_n1902# VSUBS 0.52672f **FLOATING
C1211 vref_final_0/r_vref_1/a_n200_1800# VSUBS 0.52672f **FLOATING
C1212 vref_final_0/r_vref_0/a_n200_n1902# VSUBS 0.52672f **FLOATING
C1213 vref_final_0/r_vref_0/a_n200_1800# VSUBS 0.52654f **FLOATING
C1214 pga_final_0/m2_26000_5850# VSUBS 2.91085f **FLOATING
C1215 pga_final_0/m2_18000_25850# VSUBS 6.95668f
C1216 pga_final_0/opamp_2stage_final_0/m2_7152_15850# VSUBS 3.79642f
C1217 pga_final_0/opamp_2stage_final_0/m2_14000_34400# VSUBS 39.96116f **FLOATING
C1218 pga_final_0/opamp_2stage_final_0/m7_nmos_0/a_956_n8348# VSUBS 2.01144f **FLOATING
C1219 pga_final_0/opamp_2stage_final_0/m7_nmos_0/a_n1044_n8348# VSUBS 2.01144f **FLOATING
C1220 pga_final_0/opamp_2stage_final_0/m7_nmos_0/a_556_n8440# VSUBS 0.76654f **FLOATING
C1221 pga_final_0/opamp_2stage_final_0/m7_nmos_0/a_52_n8440# VSUBS 0.71401f **FLOATING
C1222 pga_final_0/opamp_2stage_final_0/m7_nmos_0/a_n452_n8440# VSUBS 0.71401f **FLOATING
C1223 pga_final_0/opamp_2stage_final_0/m7_nmos_0/a_n956_n8440# VSUBS 0.76654f **FLOATING
C1224 pga_final_0/opamp_2stage_final_0/m7_nmos_0/a_956_n4116# VSUBS 1.99441f **FLOATING
C1225 pga_final_0/opamp_2stage_final_0/m7_nmos_0/a_n1044_n4116# VSUBS 1.99441f **FLOATING
C1226 pga_final_0/opamp_2stage_final_0/m7_nmos_0/a_556_n4208# VSUBS 0.41359f **FLOATING
C1227 pga_final_0/opamp_2stage_final_0/m7_nmos_0/a_52_n4208# VSUBS 0.36106f **FLOATING
C1228 pga_final_0/opamp_2stage_final_0/m7_nmos_0/a_n452_n4208# VSUBS 0.36106f **FLOATING
C1229 pga_final_0/opamp_2stage_final_0/m7_nmos_0/a_n956_n4208# VSUBS 0.41359f **FLOATING
C1230 pga_final_0/opamp_2stage_final_0/m7_nmos_0/a_956_116# VSUBS 1.99441f **FLOATING
C1231 pga_final_0/opamp_2stage_final_0/m7_nmos_0/a_n1044_116# VSUBS 1.99441f **FLOATING
C1232 pga_final_0/opamp_2stage_final_0/m7_nmos_0/a_556_24# VSUBS 0.41359f **FLOATING
C1233 pga_final_0/opamp_2stage_final_0/m7_nmos_0/a_52_24# VSUBS 0.36106f **FLOATING
C1234 pga_final_0/opamp_2stage_final_0/m7_nmos_0/a_n452_24# VSUBS 0.36106f **FLOATING
C1235 pga_final_0/opamp_2stage_final_0/m7_nmos_0/a_n956_24# VSUBS 0.41359f **FLOATING
C1236 pga_final_0/opamp_2stage_final_0/m7_nmos_0/a_956_4348# VSUBS 2.01517f **FLOATING
C1237 pga_final_0/opamp_2stage_final_0/m7_nmos_0/a_n1044_4348# VSUBS 2.0105f **FLOATING
C1238 pga_final_0/opamp_2stage_final_0/m7_nmos_0/a_556_4256# VSUBS 0.71164f **FLOATING
C1239 pga_final_0/opamp_2stage_final_0/m7_nmos_0/a_52_4256# VSUBS 0.65654f **FLOATING
C1240 pga_final_0/opamp_2stage_final_0/m7_nmos_0/a_n452_4256# VSUBS 0.65627f **FLOATING
C1241 pga_final_0/opamp_2stage_final_0/m7_nmos_0/a_n956_4256# VSUBS 0.7089f **FLOATING
C1242 pga_final_0/opamp_2stage_final_0/m1_nmos_0/a_956_n8348# VSUBS 2.01144f **FLOATING
C1243 pga_final_0/opamp_2stage_final_0/m1_nmos_0/a_n1044_n8348# VSUBS 2.01144f **FLOATING
C1244 pga_final_0/opamp_2stage_final_0/m1_nmos_0/a_556_n8440# VSUBS 0.76654f **FLOATING
C1245 pga_final_0/opamp_2stage_final_0/m1_nmos_0/a_52_n8440# VSUBS 0.71401f **FLOATING
C1246 pga_final_0/opamp_2stage_final_0/m1_nmos_0/a_n452_n8440# VSUBS 0.71401f **FLOATING
C1247 pga_final_0/opamp_2stage_final_0/m1_nmos_0/a_n956_n8440# VSUBS 0.76654f **FLOATING
C1248 pga_final_0/opamp_2stage_final_0/m1_nmos_0/a_956_n4116# VSUBS 1.99441f **FLOATING
C1249 pga_final_0/opamp_2stage_final_0/m1_nmos_0/a_n1044_n4116# VSUBS 1.99441f **FLOATING
C1250 pga_final_0/opamp_2stage_final_0/m1_nmos_0/a_556_n4208# VSUBS 0.41359f **FLOATING
C1251 pga_final_0/opamp_2stage_final_0/m1_nmos_0/a_52_n4208# VSUBS 0.36106f **FLOATING
C1252 pga_final_0/opamp_2stage_final_0/m1_nmos_0/a_n452_n4208# VSUBS 0.36106f **FLOATING
C1253 pga_final_0/opamp_2stage_final_0/m1_nmos_0/a_n956_n4208# VSUBS 0.41359f **FLOATING
C1254 pga_final_0/opamp_2stage_final_0/m1_nmos_0/a_956_116# VSUBS 1.99441f **FLOATING
C1255 pga_final_0/opamp_2stage_final_0/m1_nmos_0/a_n1044_116# VSUBS 1.99441f **FLOATING
C1256 pga_final_0/opamp_2stage_final_0/m1_nmos_0/a_556_24# VSUBS 0.41359f **FLOATING
C1257 pga_final_0/opamp_2stage_final_0/m1_nmos_0/a_52_24# VSUBS 0.36106f **FLOATING
C1258 pga_final_0/opamp_2stage_final_0/m1_nmos_0/a_n452_24# VSUBS 0.36106f **FLOATING
C1259 pga_final_0/opamp_2stage_final_0/m1_nmos_0/a_n956_24# VSUBS 0.41359f **FLOATING
C1260 pga_final_0/opamp_2stage_final_0/m1_nmos_0/a_956_4348# VSUBS 2.01625f **FLOATING
C1261 pga_final_0/opamp_2stage_final_0/m1_nmos_0/a_n1044_4348# VSUBS 2.01625f **FLOATING
C1262 pga_final_0/opamp_2stage_final_0/m1_nmos_0/a_556_4256# VSUBS 0.72593f **FLOATING
C1263 pga_final_0/opamp_2stage_final_0/m1_nmos_0/a_52_4256# VSUBS 0.67103f **FLOATING
C1264 pga_final_0/opamp_2stage_final_0/m1_nmos_0/a_n452_4256# VSUBS 0.67059f **FLOATING
C1265 pga_final_0/opamp_2stage_final_0/m1_nmos_0/a_n956_4256# VSUBS 0.7255f **FLOATING
C1266 pga_final_0/opamp_2stage_final_0/m4_pmos_0/a_556_n4440# VSUBS 0.06321f **FLOATING
C1267 pga_final_0/opamp_2stage_final_0/m4_pmos_0/a_52_n4440# VSUBS 0.05342f **FLOATING
C1268 pga_final_0/opamp_2stage_final_0/m4_pmos_0/a_n452_n4440# VSUBS 0.05342f **FLOATING
C1269 pga_final_0/opamp_2stage_final_0/m4_pmos_0/a_n956_n4440# VSUBS 0.06321f **FLOATING
C1270 pga_final_0/opamp_2stage_final_0/m4_pmos_0/a_556_2256# VSUBS 0.06321f **FLOATING
C1271 pga_final_0/opamp_2stage_final_0/m4_pmos_0/a_52_2256# VSUBS 0.05342f **FLOATING
C1272 pga_final_0/opamp_2stage_final_0/m4_pmos_0/a_n452_2256# VSUBS 0.05342f **FLOATING
C1273 pga_final_0/opamp_2stage_final_0/m4_pmos_0/a_n956_2256# VSUBS 0.06321f **FLOATING
C1274 pga_final_0/opamp_2stage_final_0/m4_pmos_0/w_n1220_n4604# VSUBS 71.1437f **FLOATING
C1275 pga_final_0/opamp_2stage_final_0/m3_pmos_0/a_556_n4440# VSUBS 0.06321f **FLOATING
C1276 pga_final_0/opamp_2stage_final_0/m3_pmos_0/a_52_n4440# VSUBS 0.05342f **FLOATING
C1277 pga_final_0/opamp_2stage_final_0/m3_pmos_0/a_n452_n4440# VSUBS 0.05342f **FLOATING
C1278 pga_final_0/opamp_2stage_final_0/m3_pmos_0/a_n956_n4440# VSUBS 0.06321f **FLOATING
C1279 pga_final_0/opamp_2stage_final_0/m3_pmos_0/a_556_2256# VSUBS 0.06321f **FLOATING
C1280 pga_final_0/opamp_2stage_final_0/m3_pmos_0/a_52_2256# VSUBS 0.05342f **FLOATING
C1281 pga_final_0/opamp_2stage_final_0/m3_pmos_0/a_n452_2256# VSUBS 0.05342f **FLOATING
C1282 pga_final_0/opamp_2stage_final_0/m3_pmos_0/a_n956_2256# VSUBS 0.06321f **FLOATING
C1283 pga_final_0/opamp_2stage_final_0/m3_pmos_0/w_n1220_n4604# VSUBS 71.1437f **FLOATING
C1284 pga_final_0/opamp_2stage_final_0/m5_nmos_0/a_956_n4348# VSUBS 1.01566f **FLOATING
C1285 pga_final_0/opamp_2stage_final_0/m5_nmos_0/a_n1044_n4348# VSUBS 1.01566f **FLOATING
C1286 pga_final_0/opamp_2stage_final_0/m5_nmos_0/a_556_n4440# VSUBS 0.7066f **FLOATING
C1287 pga_final_0/opamp_2stage_final_0/m5_nmos_0/a_52_n4440# VSUBS 0.65407f **FLOATING
C1288 pga_final_0/opamp_2stage_final_0/m5_nmos_0/a_n452_n4440# VSUBS 0.65407f **FLOATING
C1289 pga_final_0/opamp_2stage_final_0/m5_nmos_0/a_n956_n4440# VSUBS 0.7066f **FLOATING
C1290 pga_final_0/opamp_2stage_final_0/m5_nmos_0/a_956_n2116# VSUBS 0.99972f **FLOATING
C1291 pga_final_0/opamp_2stage_final_0/m5_nmos_0/a_n1044_n2116# VSUBS 0.99972f **FLOATING
C1292 pga_final_0/opamp_2stage_final_0/m5_nmos_0/a_556_n2208# VSUBS 0.41359f **FLOATING
C1293 pga_final_0/opamp_2stage_final_0/m5_nmos_0/a_52_n2208# VSUBS 0.36106f **FLOATING
C1294 pga_final_0/opamp_2stage_final_0/m5_nmos_0/a_n452_n2208# VSUBS 0.36106f **FLOATING
C1295 pga_final_0/opamp_2stage_final_0/m5_nmos_0/a_n956_n2208# VSUBS 0.41359f **FLOATING
C1296 pga_final_0/opamp_2stage_final_0/m5_nmos_0/a_956_116# VSUBS 0.99972f **FLOATING
C1297 pga_final_0/opamp_2stage_final_0/m5_nmos_0/a_n1044_116# VSUBS 0.99972f **FLOATING
C1298 pga_final_0/opamp_2stage_final_0/m5_nmos_0/a_556_24# VSUBS 0.41359f **FLOATING
C1299 pga_final_0/opamp_2stage_final_0/m5_nmos_0/a_52_24# VSUBS 0.36106f **FLOATING
C1300 pga_final_0/opamp_2stage_final_0/m5_nmos_0/a_n452_24# VSUBS 0.36106f **FLOATING
C1301 pga_final_0/opamp_2stage_final_0/m5_nmos_0/a_n956_24# VSUBS 0.41359f **FLOATING
C1302 pga_final_0/opamp_2stage_final_0/m5_nmos_0/a_956_2348# VSUBS 1.01566f **FLOATING
C1303 pga_final_0/opamp_2stage_final_0/m5_nmos_0/a_n1044_2348# VSUBS 1.01566f **FLOATING
C1304 pga_final_0/opamp_2stage_final_0/m5_nmos_0/a_556_2256# VSUBS 0.7066f **FLOATING
C1305 pga_final_0/opamp_2stage_final_0/m5_nmos_0/a_52_2256# VSUBS 0.65407f **FLOATING
C1306 pga_final_0/opamp_2stage_final_0/m5_nmos_0/a_n452_2256# VSUBS 0.65407f **FLOATING
C1307 pga_final_0/opamp_2stage_final_0/m5_nmos_0/a_n956_2256# VSUBS 0.7066f **FLOATING
C1308 pga_final_0/opamp_2stage_final_0/m6_pmos_0/a_356_n16440# VSUBS 2.37022f **FLOATING
C1309 pga_final_0/opamp_2stage_final_0/m6_pmos_0/a_52_n16440# VSUBS 2.31745f **FLOATING
C1310 pga_final_0/opamp_2stage_final_0/m6_pmos_0/a_n252_n16440# VSUBS 2.31935f **FLOATING
C1311 pga_final_0/opamp_2stage_final_0/m6_pmos_0/a_n556_n16440# VSUBS 2.37252f **FLOATING
C1312 pga_final_0/opamp_2stage_final_0/m6_pmos_0/a_556_n8116# VSUBS 4.72133f **FLOATING
C1313 pga_final_0/opamp_2stage_final_0/m6_pmos_0/a_252_n8116# VSUBS 1.30581f **FLOATING
C1314 pga_final_0/opamp_2stage_final_0/m6_pmos_0/a_n52_n8116# VSUBS 1.30578f **FLOATING
C1315 pga_final_0/opamp_2stage_final_0/m6_pmos_0/a_n356_n8116# VSUBS 1.30581f **FLOATING
C1316 pga_final_0/opamp_2stage_final_0/m6_pmos_0/a_n644_n8116# VSUBS 4.72133f **FLOATING
C1317 pga_final_0/opamp_2stage_final_0/m6_pmos_0/a_356_n8208# VSUBS 0.31142f **FLOATING
C1318 pga_final_0/opamp_2stage_final_0/m6_pmos_0/a_52_n8208# VSUBS 0.26083f **FLOATING
C1319 pga_final_0/opamp_2stage_final_0/m6_pmos_0/a_n252_n8208# VSUBS 0.26083f **FLOATING
C1320 pga_final_0/opamp_2stage_final_0/m6_pmos_0/a_n556_n8208# VSUBS 0.31142f **FLOATING
C1321 pga_final_0/opamp_2stage_final_0/m6_pmos_0/a_556_116# VSUBS 4.72381f **FLOATING
C1322 pga_final_0/opamp_2stage_final_0/m6_pmos_0/a_252_116# VSUBS 1.30923f **FLOATING
C1323 pga_final_0/opamp_2stage_final_0/m6_pmos_0/a_n52_116# VSUBS 1.3092f **FLOATING
C1324 pga_final_0/opamp_2stage_final_0/m6_pmos_0/a_n356_116# VSUBS 1.30923f **FLOATING
C1325 pga_final_0/opamp_2stage_final_0/m6_pmos_0/a_n644_116# VSUBS 4.72381f **FLOATING
C1326 pga_final_0/opamp_2stage_final_0/m6_pmos_0/a_356_24# VSUBS 0.3117f **FLOATING
C1327 pga_final_0/opamp_2stage_final_0/m6_pmos_0/a_52_24# VSUBS 0.26111f **FLOATING
C1328 pga_final_0/opamp_2stage_final_0/m6_pmos_0/a_n252_24# VSUBS 0.26111f **FLOATING
C1329 pga_final_0/opamp_2stage_final_0/m6_pmos_0/a_n556_24# VSUBS 0.3117f **FLOATING
C1330 pga_final_0/opamp_2stage_final_0/m6_pmos_0/a_356_8256# VSUBS 2.61685f **FLOATING
C1331 pga_final_0/opamp_2stage_final_0/m6_pmos_0/a_52_8256# VSUBS 2.56626f **FLOATING
C1332 pga_final_0/opamp_2stage_final_0/m6_pmos_0/a_n252_8256# VSUBS 2.56626f **FLOATING
C1333 pga_final_0/opamp_2stage_final_0/m6_pmos_0/a_n556_8256# VSUBS 2.64406f **FLOATING
C1334 pga_final_0/opamp_2stage_final_0/m2_nmos_0/a_956_n8348# VSUBS 2.01144f **FLOATING
C1335 pga_final_0/opamp_2stage_final_0/m2_nmos_0/a_n1044_n8348# VSUBS 2.01144f **FLOATING
C1336 pga_final_0/opamp_2stage_final_0/m2_nmos_0/a_556_n8440# VSUBS 0.76654f **FLOATING
C1337 pga_final_0/opamp_2stage_final_0/m2_nmos_0/a_52_n8440# VSUBS 0.71401f **FLOATING
C1338 pga_final_0/opamp_2stage_final_0/m2_nmos_0/a_n452_n8440# VSUBS 0.71401f **FLOATING
C1339 pga_final_0/opamp_2stage_final_0/m2_nmos_0/a_n956_n8440# VSUBS 0.76654f **FLOATING
C1340 pga_final_0/opamp_2stage_final_0/m2_nmos_0/a_956_n4116# VSUBS 1.99441f **FLOATING
C1341 pga_final_0/opamp_2stage_final_0/m2_nmos_0/a_n1044_n4116# VSUBS 1.99441f **FLOATING
C1342 pga_final_0/opamp_2stage_final_0/m2_nmos_0/a_556_n4208# VSUBS 0.41359f **FLOATING
C1343 pga_final_0/opamp_2stage_final_0/m2_nmos_0/a_52_n4208# VSUBS 0.36106f **FLOATING
C1344 pga_final_0/opamp_2stage_final_0/m2_nmos_0/a_n452_n4208# VSUBS 0.36106f **FLOATING
C1345 pga_final_0/opamp_2stage_final_0/m2_nmos_0/a_n956_n4208# VSUBS 0.41359f **FLOATING
C1346 pga_final_0/opamp_2stage_final_0/m2_nmos_0/a_956_116# VSUBS 1.99441f **FLOATING
C1347 pga_final_0/opamp_2stage_final_0/m2_nmos_0/a_n1044_116# VSUBS 1.99441f **FLOATING
C1348 pga_final_0/opamp_2stage_final_0/m2_nmos_0/a_556_24# VSUBS 0.41359f **FLOATING
C1349 pga_final_0/opamp_2stage_final_0/m2_nmos_0/a_52_24# VSUBS 0.36106f **FLOATING
C1350 pga_final_0/opamp_2stage_final_0/m2_nmos_0/a_n452_24# VSUBS 0.36106f **FLOATING
C1351 pga_final_0/opamp_2stage_final_0/m2_nmos_0/a_n956_24# VSUBS 0.41359f **FLOATING
C1352 pga_final_0/opamp_2stage_final_0/m2_nmos_0/a_956_4348# VSUBS 2.01625f **FLOATING
C1353 pga_final_0/opamp_2stage_final_0/m2_nmos_0/a_n1044_4348# VSUBS 2.01625f **FLOATING
C1354 pga_final_0/opamp_2stage_final_0/m2_nmos_0/a_556_4256# VSUBS 0.72593f **FLOATING
C1355 pga_final_0/opamp_2stage_final_0/m2_nmos_0/a_52_4256# VSUBS 0.67103f **FLOATING
C1356 pga_final_0/opamp_2stage_final_0/m2_nmos_0/a_n452_4256# VSUBS 0.67103f **FLOATING
C1357 pga_final_0/opamp_2stage_final_0/m2_nmos_0/a_n956_4256# VSUBS 0.72593f **FLOATING
C1358 pga_final_0/r_fb_0/a_n200_n8102# VSUBS 0.57842f **FLOATING
C1359 pga_final_0/r_fb_0/a_n200_8000# VSUBS 0.52654f **FLOATING
C1360 pga_final_0/r_in_0/a_n200_n902# VSUBS 0.52654f **FLOATING
C1361 pga_final_0/r_in_0/a_n200_800# VSUBS 0.5277f **FLOATING
C1362 bias_final_0/m2_n100_6000# VSUBS 7.10921f
C1363 bias_final_0/bias_nmos_1/a_452_n1716# VSUBS 0.81673f **FLOATING
C1364 bias_final_0/bias_nmos_1/a_n540_n1716# VSUBS 0.81673f **FLOATING
C1365 bias_final_0/bias_nmos_1/a_52_n1808# VSUBS 0.70804f **FLOATING
C1366 bias_final_0/bias_nmos_1/a_n452_n1808# VSUBS 0.70804f **FLOATING
C1367 bias_final_0/bias_nmos_1/a_452_116# VSUBS 0.81673f **FLOATING
C1368 bias_final_0/bias_nmos_1/a_n540_116# VSUBS 0.81673f **FLOATING
C1369 bias_final_0/bias_nmos_1/a_52_24# VSUBS 0.70804f **FLOATING
C1370 bias_final_0/bias_nmos_1/a_n452_24# VSUBS 0.70804f **FLOATING
C1371 bias_final_0/bias_nmos_0/a_452_n1716# VSUBS 0.81673f **FLOATING
C1372 bias_final_0/bias_nmos_0/a_n540_n1716# VSUBS 0.81673f **FLOATING
C1373 bias_final_0/bias_nmos_0/a_52_n1808# VSUBS 0.70804f **FLOATING
C1374 bias_final_0/bias_nmos_0/a_n452_n1808# VSUBS 0.70804f **FLOATING
C1375 bias_final_0/bias_nmos_0/a_452_116# VSUBS 0.81673f **FLOATING
C1376 bias_final_0/bias_nmos_0/a_n540_116# VSUBS 0.81673f **FLOATING
C1377 bias_final_0/bias_nmos_0/a_52_24# VSUBS 0.70804f **FLOATING
C1378 bias_final_0/bias_nmos_0/a_n452_24# VSUBS 0.70804f **FLOATING
C1379 sh_final_0/m2_30000_19850# VSUBS 9.00345f **FLOATING
C1380 sh_final_0/sw_nmos_1/a_100_n400# VSUBS 0.43367f **FLOATING
C1381 sh_final_0/sw_nmos_1/a_n188_n400# VSUBS 0.43367f **FLOATING
C1382 sh_final_0/sw_nmos_1/a_n100_n492# VSUBS 0.59394f **FLOATING
C1383 sh_final_0/sw_nmos_0/a_100_n400# VSUBS 0.43367f **FLOATING
C1384 sh_final_0/sw_nmos_0/a_n188_n400# VSUBS 0.43367f **FLOATING
C1385 sh_final_0/sw_nmos_0/a_n100_n492# VSUBS 0.59394f **FLOATING
C1386 sh_final_0/opamp_2stage_final_0/m2_7152_15850# VSUBS 3.60093f
C1387 sh_final_0/opamp_2stage_final_0/m7_nmos_0/a_956_n8348# VSUBS 2.01144f **FLOATING
C1388 sh_final_0/opamp_2stage_final_0/m7_nmos_0/a_n1044_n8348# VSUBS 2.01144f **FLOATING
C1389 sh_final_0/opamp_2stage_final_0/m7_nmos_0/a_556_n8440# VSUBS 0.76654f **FLOATING
C1390 sh_final_0/opamp_2stage_final_0/m7_nmos_0/a_52_n8440# VSUBS 0.71401f **FLOATING
C1391 sh_final_0/opamp_2stage_final_0/m7_nmos_0/a_n452_n8440# VSUBS 0.71401f **FLOATING
C1392 sh_final_0/opamp_2stage_final_0/m7_nmos_0/a_n956_n8440# VSUBS 0.76654f **FLOATING
C1393 sh_final_0/opamp_2stage_final_0/m7_nmos_0/a_956_n4116# VSUBS 1.99441f **FLOATING
C1394 sh_final_0/opamp_2stage_final_0/m7_nmos_0/a_n1044_n4116# VSUBS 1.99441f **FLOATING
C1395 sh_final_0/opamp_2stage_final_0/m7_nmos_0/a_556_n4208# VSUBS 0.41359f **FLOATING
C1396 sh_final_0/opamp_2stage_final_0/m7_nmos_0/a_52_n4208# VSUBS 0.36106f **FLOATING
C1397 sh_final_0/opamp_2stage_final_0/m7_nmos_0/a_n452_n4208# VSUBS 0.36106f **FLOATING
C1398 sh_final_0/opamp_2stage_final_0/m7_nmos_0/a_n956_n4208# VSUBS 0.41359f **FLOATING
C1399 sh_final_0/opamp_2stage_final_0/m7_nmos_0/a_956_116# VSUBS 1.99441f **FLOATING
C1400 sh_final_0/opamp_2stage_final_0/m7_nmos_0/a_n1044_116# VSUBS 1.99441f **FLOATING
C1401 sh_final_0/opamp_2stage_final_0/m7_nmos_0/a_556_24# VSUBS 0.41359f **FLOATING
C1402 sh_final_0/opamp_2stage_final_0/m7_nmos_0/a_52_24# VSUBS 0.36106f **FLOATING
C1403 sh_final_0/opamp_2stage_final_0/m7_nmos_0/a_n452_24# VSUBS 0.36106f **FLOATING
C1404 sh_final_0/opamp_2stage_final_0/m7_nmos_0/a_n956_24# VSUBS 0.41359f **FLOATING
C1405 sh_final_0/opamp_2stage_final_0/m7_nmos_0/a_956_4348# VSUBS 2.01517f **FLOATING
C1406 sh_final_0/opamp_2stage_final_0/m7_nmos_0/a_n1044_4348# VSUBS 2.01035f **FLOATING
C1407 sh_final_0/opamp_2stage_final_0/m7_nmos_0/a_556_4256# VSUBS 0.71164f **FLOATING
C1408 sh_final_0/opamp_2stage_final_0/m7_nmos_0/a_52_4256# VSUBS 0.65654f **FLOATING
C1409 sh_final_0/opamp_2stage_final_0/m7_nmos_0/a_n452_4256# VSUBS 0.65428f **FLOATING
C1410 sh_final_0/opamp_2stage_final_0/m7_nmos_0/a_n956_4256# VSUBS 0.7066f **FLOATING
C1411 sh_final_0/opamp_2stage_final_0/m1_nmos_0/a_956_n8348# VSUBS 2.01144f **FLOATING
C1412 sh_final_0/opamp_2stage_final_0/m1_nmos_0/a_n1044_n8348# VSUBS 2.01144f **FLOATING
C1413 sh_final_0/opamp_2stage_final_0/m1_nmos_0/a_556_n8440# VSUBS 0.76654f **FLOATING
C1414 sh_final_0/opamp_2stage_final_0/m1_nmos_0/a_52_n8440# VSUBS 0.71401f **FLOATING
C1415 sh_final_0/opamp_2stage_final_0/m1_nmos_0/a_n452_n8440# VSUBS 0.71401f **FLOATING
C1416 sh_final_0/opamp_2stage_final_0/m1_nmos_0/a_n956_n8440# VSUBS 0.76654f **FLOATING
C1417 sh_final_0/opamp_2stage_final_0/m1_nmos_0/a_956_n4116# VSUBS 1.99441f **FLOATING
C1418 sh_final_0/opamp_2stage_final_0/m1_nmos_0/a_n1044_n4116# VSUBS 1.99441f **FLOATING
C1419 sh_final_0/opamp_2stage_final_0/m1_nmos_0/a_556_n4208# VSUBS 0.41359f **FLOATING
C1420 sh_final_0/opamp_2stage_final_0/m1_nmos_0/a_52_n4208# VSUBS 0.36106f **FLOATING
C1421 sh_final_0/opamp_2stage_final_0/m1_nmos_0/a_n452_n4208# VSUBS 0.36106f **FLOATING
C1422 sh_final_0/opamp_2stage_final_0/m1_nmos_0/a_n956_n4208# VSUBS 0.41359f **FLOATING
C1423 sh_final_0/opamp_2stage_final_0/m1_nmos_0/a_956_116# VSUBS 1.99441f **FLOATING
C1424 sh_final_0/opamp_2stage_final_0/m1_nmos_0/a_n1044_116# VSUBS 1.99441f **FLOATING
C1425 sh_final_0/opamp_2stage_final_0/m1_nmos_0/a_556_24# VSUBS 0.41359f **FLOATING
C1426 sh_final_0/opamp_2stage_final_0/m1_nmos_0/a_52_24# VSUBS 0.36106f **FLOATING
C1427 sh_final_0/opamp_2stage_final_0/m1_nmos_0/a_n452_24# VSUBS 0.36106f **FLOATING
C1428 sh_final_0/opamp_2stage_final_0/m1_nmos_0/a_n956_24# VSUBS 0.41359f **FLOATING
C1429 sh_final_0/opamp_2stage_final_0/m1_nmos_0/a_956_4348# VSUBS 2.01625f **FLOATING
C1430 sh_final_0/opamp_2stage_final_0/m1_nmos_0/a_n1044_4348# VSUBS 2.01625f **FLOATING
C1431 sh_final_0/opamp_2stage_final_0/m1_nmos_0/a_556_4256# VSUBS 0.7255f **FLOATING
C1432 sh_final_0/opamp_2stage_final_0/m1_nmos_0/a_52_4256# VSUBS 0.67059f **FLOATING
C1433 sh_final_0/opamp_2stage_final_0/m1_nmos_0/a_n452_4256# VSUBS 0.67059f **FLOATING
C1434 sh_final_0/opamp_2stage_final_0/m1_nmos_0/a_n956_4256# VSUBS 0.7255f **FLOATING
C1435 sh_final_0/opamp_2stage_final_0/m4_pmos_0/a_556_n4440# VSUBS 0.06321f **FLOATING
C1436 sh_final_0/opamp_2stage_final_0/m4_pmos_0/a_52_n4440# VSUBS 0.05342f **FLOATING
C1437 sh_final_0/opamp_2stage_final_0/m4_pmos_0/a_n452_n4440# VSUBS 0.05342f **FLOATING
C1438 sh_final_0/opamp_2stage_final_0/m4_pmos_0/a_n956_n4440# VSUBS 0.06321f **FLOATING
C1439 sh_final_0/opamp_2stage_final_0/m4_pmos_0/a_556_2256# VSUBS 0.06321f **FLOATING
C1440 sh_final_0/opamp_2stage_final_0/m4_pmos_0/a_52_2256# VSUBS 0.05342f **FLOATING
C1441 sh_final_0/opamp_2stage_final_0/m4_pmos_0/a_n452_2256# VSUBS 0.05342f **FLOATING
C1442 sh_final_0/opamp_2stage_final_0/m4_pmos_0/a_n956_2256# VSUBS 0.06321f **FLOATING
C1443 sh_final_0/opamp_2stage_final_0/m4_pmos_0/w_n1220_n4604# VSUBS 71.1437f **FLOATING
C1444 sh_final_0/opamp_2stage_final_0/m3_pmos_0/a_556_n4440# VSUBS 0.06321f **FLOATING
C1445 sh_final_0/opamp_2stage_final_0/m3_pmos_0/a_52_n4440# VSUBS 0.05342f **FLOATING
C1446 sh_final_0/opamp_2stage_final_0/m3_pmos_0/a_n452_n4440# VSUBS 0.05342f **FLOATING
C1447 sh_final_0/opamp_2stage_final_0/m3_pmos_0/a_n956_n4440# VSUBS 0.06321f **FLOATING
C1448 sh_final_0/opamp_2stage_final_0/m3_pmos_0/a_556_2256# VSUBS 0.06321f **FLOATING
C1449 sh_final_0/opamp_2stage_final_0/m3_pmos_0/a_52_2256# VSUBS 0.05342f **FLOATING
C1450 sh_final_0/opamp_2stage_final_0/m3_pmos_0/a_n452_2256# VSUBS 0.05342f **FLOATING
C1451 sh_final_0/opamp_2stage_final_0/m3_pmos_0/a_n956_2256# VSUBS 0.06321f **FLOATING
C1452 sh_final_0/opamp_2stage_final_0/m3_pmos_0/w_n1220_n4604# VSUBS 71.1437f **FLOATING
C1453 sh_final_0/opamp_2stage_final_0/m5_nmos_0/a_956_n4348# VSUBS 1.01566f **FLOATING
C1454 sh_final_0/opamp_2stage_final_0/m5_nmos_0/a_n1044_n4348# VSUBS 1.01566f **FLOATING
C1455 sh_final_0/opamp_2stage_final_0/m5_nmos_0/a_556_n4440# VSUBS 0.7066f **FLOATING
C1456 sh_final_0/opamp_2stage_final_0/m5_nmos_0/a_52_n4440# VSUBS 0.65407f **FLOATING
C1457 sh_final_0/opamp_2stage_final_0/m5_nmos_0/a_n452_n4440# VSUBS 0.65407f **FLOATING
C1458 sh_final_0/opamp_2stage_final_0/m5_nmos_0/a_n956_n4440# VSUBS 0.7066f **FLOATING
C1459 sh_final_0/opamp_2stage_final_0/m5_nmos_0/a_956_n2116# VSUBS 0.99972f **FLOATING
C1460 sh_final_0/opamp_2stage_final_0/m5_nmos_0/a_n1044_n2116# VSUBS 0.99972f **FLOATING
C1461 sh_final_0/opamp_2stage_final_0/m5_nmos_0/a_556_n2208# VSUBS 0.41359f **FLOATING
C1462 sh_final_0/opamp_2stage_final_0/m5_nmos_0/a_52_n2208# VSUBS 0.36106f **FLOATING
C1463 sh_final_0/opamp_2stage_final_0/m5_nmos_0/a_n452_n2208# VSUBS 0.36106f **FLOATING
C1464 sh_final_0/opamp_2stage_final_0/m5_nmos_0/a_n956_n2208# VSUBS 0.41359f **FLOATING
C1465 sh_final_0/opamp_2stage_final_0/m5_nmos_0/a_956_116# VSUBS 0.99972f **FLOATING
C1466 sh_final_0/opamp_2stage_final_0/m5_nmos_0/a_n1044_116# VSUBS 0.99972f **FLOATING
C1467 sh_final_0/opamp_2stage_final_0/m5_nmos_0/a_556_24# VSUBS 0.41359f **FLOATING
C1468 sh_final_0/opamp_2stage_final_0/m5_nmos_0/a_52_24# VSUBS 0.36106f **FLOATING
C1469 sh_final_0/opamp_2stage_final_0/m5_nmos_0/a_n452_24# VSUBS 0.36106f **FLOATING
C1470 sh_final_0/opamp_2stage_final_0/m5_nmos_0/a_n956_24# VSUBS 0.41359f **FLOATING
C1471 sh_final_0/opamp_2stage_final_0/m5_nmos_0/a_956_2348# VSUBS 1.01566f **FLOATING
C1472 sh_final_0/opamp_2stage_final_0/m5_nmos_0/a_n1044_2348# VSUBS 1.01566f **FLOATING
C1473 sh_final_0/opamp_2stage_final_0/m5_nmos_0/a_556_2256# VSUBS 0.7066f **FLOATING
C1474 sh_final_0/opamp_2stage_final_0/m5_nmos_0/a_52_2256# VSUBS 0.65407f **FLOATING
C1475 sh_final_0/opamp_2stage_final_0/m5_nmos_0/a_n452_2256# VSUBS 0.65407f **FLOATING
C1476 sh_final_0/opamp_2stage_final_0/m5_nmos_0/a_n956_2256# VSUBS 0.7066f **FLOATING
C1477 sh_final_0/opamp_2stage_final_0/m1_n2152_32500# VSUBS 0.22528p **FLOATING
C1478 sh_final_0/opamp_2stage_final_0/m2_nmos_0/a_956_n8348# VSUBS 2.01144f **FLOATING
C1479 sh_final_0/opamp_2stage_final_0/m2_nmos_0/a_n1044_n8348# VSUBS 2.01144f **FLOATING
C1480 sh_final_0/opamp_2stage_final_0/m2_nmos_0/a_556_n8440# VSUBS 0.76654f **FLOATING
C1481 sh_final_0/opamp_2stage_final_0/m2_nmos_0/a_52_n8440# VSUBS 0.71401f **FLOATING
C1482 sh_final_0/opamp_2stage_final_0/m2_nmos_0/a_n452_n8440# VSUBS 0.71401f **FLOATING
C1483 sh_final_0/opamp_2stage_final_0/m2_nmos_0/a_n956_n8440# VSUBS 0.76654f **FLOATING
C1484 sh_final_0/opamp_2stage_final_0/m2_nmos_0/a_956_n4116# VSUBS 1.99441f **FLOATING
C1485 sh_final_0/opamp_2stage_final_0/m2_nmos_0/a_n1044_n4116# VSUBS 1.99441f **FLOATING
C1486 sh_final_0/opamp_2stage_final_0/m2_nmos_0/a_556_n4208# VSUBS 0.41359f **FLOATING
C1487 sh_final_0/opamp_2stage_final_0/m2_nmos_0/a_52_n4208# VSUBS 0.36106f **FLOATING
C1488 sh_final_0/opamp_2stage_final_0/m2_nmos_0/a_n452_n4208# VSUBS 0.36106f **FLOATING
C1489 sh_final_0/opamp_2stage_final_0/m2_nmos_0/a_n956_n4208# VSUBS 0.41359f **FLOATING
C1490 sh_final_0/opamp_2stage_final_0/m2_nmos_0/a_956_116# VSUBS 1.99441f **FLOATING
C1491 sh_final_0/opamp_2stage_final_0/m2_nmos_0/a_n1044_116# VSUBS 1.99441f **FLOATING
C1492 sh_final_0/opamp_2stage_final_0/m2_nmos_0/a_556_24# VSUBS 0.41359f **FLOATING
C1493 sh_final_0/opamp_2stage_final_0/m2_nmos_0/a_52_24# VSUBS 0.36106f **FLOATING
C1494 sh_final_0/opamp_2stage_final_0/m2_nmos_0/a_n452_24# VSUBS 0.36106f **FLOATING
C1495 sh_final_0/opamp_2stage_final_0/m2_nmos_0/a_n956_24# VSUBS 0.41359f **FLOATING
C1496 sh_final_0/opamp_2stage_final_0/m2_nmos_0/a_956_4348# VSUBS 2.01625f **FLOATING
C1497 sh_final_0/opamp_2stage_final_0/m2_nmos_0/a_n1044_4348# VSUBS 2.01625f **FLOATING
C1498 sh_final_0/opamp_2stage_final_0/m2_nmos_0/a_556_4256# VSUBS 0.7255f **FLOATING
C1499 sh_final_0/opamp_2stage_final_0/m2_nmos_0/a_52_4256# VSUBS 0.67059f **FLOATING
C1500 sh_final_0/opamp_2stage_final_0/m2_nmos_0/a_n452_4256# VSUBS 0.67059f **FLOATING
C1501 sh_final_0/opamp_2stage_final_0/m2_nmos_0/a_n956_4256# VSUBS 0.7255f **FLOATING
C1502 sh_final_0/c_samp_0/m4_n3120_n3000# VSUBS 11.45557f **FLOATING
C1503 sh_final_0/c_samp_0/m4_n3240_n3120# VSUBS 5.63729f **FLOATING
